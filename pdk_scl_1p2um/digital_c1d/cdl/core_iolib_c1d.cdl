* File: PDDR02.cdl
* Created: Wed May  6 11:12:12 2026
* Program "Calibre xRC"
* Version "v2017.2_16.14"
*

.subckt FILLER1 VSS VDD
.ends

.subckt FILLER2 VSS VDD
.ends

.subckt FILLER3 VSS VDD
.ends
.subckt FILLER4 VSS VDD
.ends
.subckt FILLER5 VSS VDD
.ends

.subckt PDDR02 D P_EN EN N_EN VSS VDD
M0 VDD D 7 VDD P L=1.5e-06 W=1.25e-05 AD=1.3898e-10 AS=4.625e-11 PD=8.17e-05
+ PS=3.24e-05 NRD=0.804 NRS=0.156
M1 P_EN 3 VDD VDD P L=1.5e-06 W=2.65e-05 AD=3.822e-11 AS=1.3898e-10 PD=2.74e-05
+ PS=8.17e-05 NRD=0.208491 NRS=0.14837
M2 19 7 3 VDD P L=1.5e-06 W=1.505e-05 AD=1.505e-11 AS=5.719e-11 PD=1.705e-05
+ PS=3.77e-05 NRD=0.0664452 NRS=0.136213
M3 VDD EN 19 VDD P L=1.5e-06 W=1.505e-05 AD=8.32475e-11 AS=1.505e-11 PD=4.14e-05
+ PS=1.705e-05 NRD=0.163621 NRS=0.0664452
M4 5 EN VDD VDD P L=1.5e-06 W=1.25e-05 AD=4.625e-11 AS=8.32475e-11 PD=3.24e-05
+ PS=4.14e-05 NRD=0.156 NRS=0.247241
M5 8 7 VDD VDD P L=1.5e-06 W=2e-05 AD=7.894e-11 AS=7.4e-11 PD=4.86e-05
+ PS=4.74e-05 NRD=0.0975 NRS=0.0975
M6 VDD 5 8 VDD P L=1.5e-06 W=2e-05 AD=1.12415e-10 AS=7.894e-11 PD=6.64e-05
+ PS=4.86e-05 NRD=0.0975 NRS=0.0975
M7 N_EN 8 VDD VDD P L=1.5e-06 W=2.4e-05 AD=8.002e-11 AS=1.12415e-10 PD=4.5e-05
+ PS=6.64e-05 NRD=0.122917 NRS=0.0842262
M8 VSS D 7 VSS N L=1.2e-06 W=6.5e-06 AD=6.725e-11 AS=2.405e-11 PD=4.33e-05
+ PS=2.04e-05 NRD=0.3 NRS=0.3
M9 P_EN 3 VSS VSS N L=1.2e-06 W=1.25e-05 AD=2.812e-11 AS=6.725e-11 PD=2.26e-05
+ PS=4.33e-05 NRD=0.177333 NRS=0.169333
M10 3 7 VSS VSS N L=1.2e-06 W=1.26e-05 AD=2.849e-11 AS=8.7405e-11 PD=2.28e-05
+ PS=5.29e-05 NRD=0.175926 NRS=0.169753
M11 3 EN VSS VSS N L=1.2e-06 W=1.26e-05 AD=2.849e-11 AS=8.7405e-11 PD=2.28e-05
+ PS=5.29e-05 NRD=0.175926 NRS=0.183431
M12 5 EN VSS VSS N L=1.2e-06 W=6.5e-06 AD=2.405e-11 AS=2.4375e-11 PD=2.04e-05
+ PS=2.05e-05 NRD=0.3 NRS=0.307692
M13 20 7 8 VSS N L=1.5e-06 W=6.5e-06 AD=6.175e-12 AS=2.405e-11 PD=8.4e-06
+ PS=2.04e-05 NRD=0.146154 NRS=0.3
M14 VSS 5 20 VSS N L=1.5e-06 W=6.5e-06 AD=8.058e-11 AS=6.175e-12 PD=5.02e-05
+ PS=8.4e-06 NRD=0.346154 NRS=0.146154
M15 N_EN 8 VSS VSS N L=1.2e-06 W=1.6e-05 AD=5.427e-11 AS=8.058e-11 PD=2.96e-05
+ PS=5.02e-05 NRD=0.288542 NRS=0.121875
.ends
*
*
* File: PDDR04.cdl
* Created: Wed May  6 11:12:36 2026
* Program "Calibre xRC"
* Version "v2017.2_16.14"
*
.subckt PDDR04 D P_EN EN N_EN VSS VDD
M0 VDD D 7 VDD P L=1.5e-06 W=1.25e-05 AD=9.567e-11 AS=4.625e-11 PD=5.83e-05
+ PS=3.24e-05 NRD=0.156 NRS=0.156
M1 P_EN 3 VDD VDD P L=1.5e-06 W=2e-05 AD=5.8725e-11 AS=9.567e-11 PD=3.7e-05
+ PS=5.83e-05 NRD=0.0975 NRS=0.0975
M2 19 7 3 VDD P L=1.5e-06 W=1.055e-05 AD=1.055e-11 AS=4.009e-11 PD=1.255e-05
+ PS=2.87e-05 NRD=0.0947867 NRS=0.194313
M3 VDD EN 19 VDD P L=1.5e-06 W=1.055e-05 AD=7.12625e-11 AS=1.055e-11 PD=3.73e-05
+ PS=1.255e-05 NRD=0.254344 NRS=0.0947867
M4 5 EN VDD VDD P L=1.5e-06 W=1.25e-05 AD=4.625e-11 AS=7.12625e-11 PD=3.24e-05
+ PS=3.73e-05 NRD=0.156 NRS=0.217333
M5 8 7 VDD VDD P L=1.5e-06 W=1.6e-05 AD=6.24e-11 AS=5.92e-11 PD=3.98e-05
+ PS=3.94e-05 NRD=0.121875 NRS=0.121875
M6 VDD 5 8 VDD P L=1.5e-06 W=1.6e-05 AD=8.934e-11 AS=6.24e-11 PD=5.44e-05
+ PS=3.98e-05 NRD=0.1225 NRS=0.121875
M7 N_EN 8 VDD VDD P L=1.5e-06 W=1.8e-05 AD=4.736e-11 AS=8.934e-11 PD=3.3e-05
+ PS=5.44e-05 NRD=0.1125 NRS=0.112778
M8 VSS D 7 VSS N L=1.2e-06 W=6.5e-06 AD=8.122e-11 AS=2.405e-11 PD=4.98e-05
+ PS=2.04e-05 NRD=0.3 NRS=0.3
M9 P_EN 3 VSS VSS N L=1.2e-06 W=1.555e-05 AD=4.2925e-11 AS=8.122e-11 PD=2.87e-05
+ PS=4.98e-05 NRD=0.189711 NRS=0.139409
M10 3 7 VSS VSS N L=1.2e-06 W=1.21e-05 AD=2.664e-11 AS=8.543e-11 PD=2.18e-05
+ PS=5.19e-05 NRD=0.172176 NRS=0.176768
M11 3 EN VSS VSS N L=1.2e-06 W=1.21e-05 AD=2.664e-11 AS=8.543e-11 PD=2.18e-05
+ PS=5.19e-05 NRD=0.172176 NRS=0.19101
M12 5 EN VSS VSS N L=1.2e-06 W=6.5e-06 AD=2.405e-11 AS=2.4375e-11 PD=2.04e-05
+ PS=2.05e-05 NRD=0.3 NRS=0.307692
M13 20 7 8 VSS N L=1.2e-06 W=1e-05 AD=1.1e-11 AS=3.7e-11 PD=1.22e-05 PS=2.74e-05
+ NRD=0.11 NRS=0.195
M14 VSS 5 20 VSS N L=1.2e-06 W=1e-05 AD=6.827e-11 AS=1.1e-11 PD=4.26e-05
+ PS=1.22e-05 NRD=0.208333 NRS=0.11
M15 N_EN 8 VSS VSS N L=1.2e-06 W=1.22e-05 AD=2.701e-11 AS=6.827e-11 PD=2.2e-05
+ PS=4.26e-05 NRD=0.162568 NRS=0.159836
.ends
*
*
* Design:   ADOR16
* Created:  "Fri Apr 10 20:10:37 2026"
* Vendor:   "Siemens"
* Program:  "Calibre xRC"
* Version:  "v2025.3_28.17"

*
.subckt ADOR16 B A C D E F OUT1 VSS VDD
*
*
*

M0 VDD B 10 VDD P L=1.5e-06 W=2e-05 AD=7.8e-11 AS=7.4e-11 PD=4.78e-05
+ PS=4.74e-05 NRD=0.0975 NRS=0.0975
M1 10 A VDD VDD P L=1.5e-06 W=2e-05 AD=8.1e-11 AS=7.8e-11 PD=4.82e-05
+ PS=4.78e-05 NRD=0.0975 NRS=0.0975
M2 4 C 10 VDD P L=1.5e-06 W=1.8e-05 AD=7.56e-11 AS=8.1e-11 PD=4.44e-05
+ PS=4.82e-05 NRD=0.108333 NRS=0.119444
M3 10 D 4 VDD P L=1.5e-06 W=1.8e-05 AD=6.66e-11 AS=7.56e-11 PD=4.34e-05
+ PS=4.44e-05 NRD=0.108333 NRS=0.125
M4 7 E 4 VDD P L=1.5e-06 W=1.6e-05 AD=6.72e-11 AS=5.92e-11 PD=4.04e-05
+ PS=3.94e-05 NRD=0.121875 NRS=0.121875
M5 4 F 7 VDD P L=1.5e-06 W=1.6e-05 AD=5.92e-11 AS=6.72e-11 PD=3.94e-05
+ PS=4.04e-05 NRD=0.121875 NRS=0.140625
M6 OUT1 7 VDD VDD P L=1.5e-06 W=2.2e-05 AD=6.46e-11 AS=1.0064e-10 PD=4.26e-05
+ PS=6.18e-05 NRD=0.113182 NRS=0.0886364
M7 22 B VSS VSS N L=1.2e-06 W=8e-06 AD=1.1e-11 AS=2.96e-11 PD=1.075e-05
+ PS=2.34e-05 NRD=0.171875 NRS=0.24375
M8 7 A 22 VSS N L=1.2e-06 W=8e-06 AD=3.16e-11 AS=1.1e-11 PD=2.39e-05
+ PS=1.075e-05 NRD=0.25 NRS=0.171875
M9 23 C 7 VSS N L=1.2e-06 W=8e-06 AD=8e-12 AS=3.16e-11 PD=1e-05 PS=2.39e-05
+ NRD=0.125 NRS=0.24375
M10 VSS D 23 VSS N L=1.2e-06 W=8e-06 AD=2.96e-11 AS=8e-12 PD=2.34e-05 PS=1e-05
+ NRD=0.24375 NRS=0.125
M11 24 E 7 VSS N L=1.2e-06 W=8e-06 AD=8e-12 AS=2.96e-11 PD=1e-05 PS=2.34e-05
+ NRD=0.125 NRS=0.24375
M12 VSS F 24 VSS N L=1.2e-06 W=8e-06 AD=9.2415e-11 AS=8e-12 PD=5.07e-05
+ PS=1e-05 NRD=0.34375 NRS=0.125
M13 OUT1 7 VSS VSS N L=1.2e-06 W=1.5e-05 AD=3.7875e-11 AS=9.2415e-11
+ PD=2.76e-05 PS=5.07e-05 NRD=0.308333 NRS=0.13

.ends
*
* Design:   AND201
* Created:  "Fri Apr 10 20:11:59 2026"
* Vendor:   "Siemens"
* Program:  "Calibre xRC"
* Version:  "v2025.3_28.17"

*
.subckt AND201 IN1 IN2 OUT1 VSS VDD
*
*
*

M0 5 IN1 VDD VDD P L=1.5e-06 W=7e-06 AD=2.73e-11 AS=2.59e-11 PD=2.18e-05
+ PS=2.14e-05 NRD=0.278571 NRS=0.278571
M1 VDD IN2 5 VDD P L=1.5e-06 W=7e-06 AD=8.5265e-11 AS=2.73e-11 PD=5.15e-05
+ PS=2.18e-05 NRD=0.297619 NRS=0.278571
M2 OUT1 5 VDD VDD P L=1.5e-06 W=1.6e-05 AD=4.386e-11 AS=8.5265e-11 PD=2.9e-05
+ PS=5.15e-05 NRD=0.121875 NRS=0.129167
M3 11 IN1 5 VSS N L=1.2e-06 W=5.5e-06 AD=5.5e-12 AS=2.035e-11 PD=7.5e-06
+ PS=1.84e-05 NRD=0.181818 NRS=0.354545
M4 VSS IN2 11 VSS N L=1.2e-06 W=5.5e-06 AD=5.9585e-11 AS=5.5e-12 PD=3.74e-05
+ PS=7.5e-06 NRD=0.363636 NRS=0.181818
M5 OUT1 5 VSS VSS N L=1.2e-06 W=8.95e-06 AD=1.4985e-11 AS=5.9585e-11
+ PD=1.55e-05 PS=3.74e-05 NRD=0.217877 NRS=0.2413

.ends
*
* Design:   AND301
* Created:  "Fri Apr 10 20:12:39 2026"
* Vendor:   "Siemens"
* Program:  "Calibre xRC"
* Version:  "v2025.3_28.17"

*
.subckt AND301 IN3 IN2 IN1 OUT1 VDD VSS
*
*
*

M0 5 IN3 VDD VDD P L=1.5e-06 W=1.3e-05 AD=5.07e-11 AS=4.81e-11 PD=3.38e-05
+ PS=3.34e-05 NRD=0.15 NRS=0.15
M1 VDD IN2 5 VDD P L=1.5e-06 W=1.3e-05 AD=5.07e-11 AS=5.07e-11 PD=3.38e-05
+ PS=3.38e-05 NRD=0.15 NRS=0.15
M2 5 IN1 VDD VDD P L=1.5e-06 W=1.3e-05 AD=4.81e-11 AS=5.07e-11 PD=3.34e-05
+ PS=3.38e-05 NRD=0.15 NRS=0.15
M3 OUT1 5 VDD VDD P L=1.5e-06 W=1.7e-05 AD=6.29e-11 AS=6.29e-11 PD=4.14e-05
+ PS=4.14e-05 NRD=0.114706 NRS=0.114706
M4 14 IN3 VSS VSS N L=1.2e-06 W=1e-05 AD=1e-11 AS=3.7e-11 PD=1.2e-05
+ PS=2.74e-05 NRD=0.1 NRS=0.195
M5 15 IN2 14 VSS N L=1.2e-06 W=1e-05 AD=1e-11 AS=1e-11 PD=1.2e-05 PS=1.2e-05
+ NRD=0.1 NRS=0.1
M6 5 IN1 15 VSS N L=1.2e-06 W=1e-05 AD=3.7e-11 AS=1e-11 PD=2.74e-05 PS=1.2e-05
+ NRD=0.195 NRS=0.1
M7 OUT1 5 VSS VSS N L=1.2e-06 W=8e-06 AD=2.96e-11 AS=2.96e-11 PD=2.34e-05
+ PS=2.34e-05 NRD=0.24375 NRS=0.24375

.ends
*
* Design:   AND401
* Created:  "Fri Apr 10 20:13:33 2026"
* Vendor:   "Siemens"
* Program:  "Calibre xRC"
* Version:  "v2025.3_28.17"

*
.subckt AND401 IN4 IN3 IN2 IN1 OUT1 VDD VSS
*
*
*

M0 6 IN4 VDD VDD P L=1.5e-06 W=1.2e-05 AD=4.68e-11 AS=4.44e-11 PD=3.18e-05
+ PS=3.14e-05 NRD=0.1625 NRS=0.1625
M1 VDD IN3 6 VDD P L=1.5e-06 W=1.2e-05 AD=4.68e-11 AS=4.68e-11 PD=3.18e-05
+ PS=3.18e-05 NRD=0.1625 NRS=0.1625
M2 6 IN2 VDD VDD P L=1.5e-06 W=1.2e-05 AD=4.68e-11 AS=4.68e-11 PD=3.18e-05
+ PS=3.18e-05 NRD=0.1625 NRS=0.1625
M3 VDD IN1 6 VDD P L=1.5e-06 W=1.2e-05 AD=4.44e-11 AS=4.68e-11 PD=3.14e-05
+ PS=3.18e-05 NRD=0.1625 NRS=0.1625
M4 OUT1 6 VDD VDD P L=1.5e-06 W=1.9e-05 AD=7.03e-11 AS=7.03e-11 PD=4.54e-05
+ PS=4.54e-05 NRD=0.102632 NRS=0.102632
M5 15 IN4 VSS VSS N L=1.2e-06 W=1.2e-05 AD=1.2e-11 AS=4.44e-11 PD=1.4e-05
+ PS=3.14e-05 NRD=0.0833333 NRS=0.1625
M6 16 IN3 15 VSS N L=1.2e-06 W=1.2e-05 AD=1.62e-11 AS=1.2e-11 PD=1.47e-05
+ PS=1.4e-05 NRD=0.1125 NRS=0.0833333
M7 17 IN2 16 VSS N L=1.2e-06 W=1.2e-05 AD=1.62e-11 AS=1.62e-11 PD=1.47e-05
+ PS=1.47e-05 NRD=0.1125 NRS=0.1125
M8 6 IN1 17 VSS N L=1.2e-06 W=1.2e-05 AD=4.44e-11 AS=1.62e-11 PD=3.14e-05
+ PS=1.47e-05 NRD=0.1625 NRS=0.1125
M9 OUT1 6 VSS VSS N L=1.2e-06 W=1e-05 AD=3.7e-11 AS=3.7e-11 PD=2.74e-05
+ PS=2.74e-05 NRD=0.195 NRS=0.195

.ends
*
* Design:   AND501
* Created:  "Fri Apr 10 20:14:22 2026"
* Vendor:   "Siemens"
* Program:  "Calibre xRC"
* Version:  "v2025.3_28.17"

*
.subckt AND501 IN5 IN4 IN3 IN2 IN1 OUT1 VDD VSS
*
*
*

M0 VDD IN5 7 VDD P L=1.5e-06 W=1.3e-05 AD=5.07e-11 AS=4.81e-11 PD=3.38e-05
+ PS=3.34e-05 NRD=0.15 NRS=0.15
M1 7 IN4 VDD VDD P L=1.5e-06 W=1.3e-05 AD=5.07e-11 AS=5.07e-11 PD=3.38e-05
+ PS=3.38e-05 NRD=0.15 NRS=0.15
M2 VDD IN3 7 VDD P L=1.5e-06 W=1.3e-05 AD=5.07e-11 AS=5.07e-11 PD=3.38e-05
+ PS=3.38e-05 NRD=0.15 NRS=0.15
M3 7 IN2 VDD VDD P L=1.5e-06 W=1.3e-05 AD=5.85e-11 AS=5.07e-11 PD=3.5e-05
+ PS=3.38e-05 NRD=0.15 NRS=0.15
M4 VDD IN1 7 VDD P L=1.5e-06 W=1.3e-05 AD=1.236e-10 AS=5.85e-11 PD=5.9e-05
+ PS=3.5e-05 NRD=0.15 NRS=0.196154
M5 OUT1 7 VDD VDD P L=1.5e-06 W=2.2e-05 AD=8.8e-11 AS=1.236e-10 PD=5.2e-05
+ PS=5.9e-05 NRD=0.102273 NRS=0.115909
M6 17 IN5 VSS VSS N L=1.2e-06 W=1.3e-05 AD=1.3e-11 AS=4.81e-11 PD=1.5e-05
+ PS=3.34e-05 NRD=0.0769231 NRS=0.15
M7 18 IN4 17 VSS N L=1.2e-06 W=1.3e-05 AD=1.3e-11 AS=1.3e-11 PD=1.5e-05
+ PS=1.5e-05 NRD=0.0769231 NRS=0.0769231
M8 19 IN3 18 VSS N L=1.2e-06 W=1.3e-05 AD=1.3e-11 AS=1.3e-11 PD=1.5e-05
+ PS=1.5e-05 NRD=0.0769231 NRS=0.0769231
M9 20 IN2 19 VSS N L=1.2e-06 W=1.3e-05 AD=2.10915e-11 AS=1.3e-11 PD=1.90221e-05
+ PS=1.5e-05 NRD=0.265385 NRS=0.0769231
M10 7 IN1 20 VSS N L=1.2e-06 W=1.3e-05 AD=2.997e-11 AS=2.10915e-11 PD=2.36e-05
+ PS=1.90221e-05 NRD=0.185897 NRS=0.219231
M11 OUT1 7 VSS VSS N L=1.2e-06 W=1.1e-05 AD=4.07e-11 AS=4.07e-11 PD=2.94e-05
+ PS=2.94e-05 NRD=0.177273 NRS=0.177273

.ends
*
* Design:   AND601
* Created:  "Fri Apr 10 20:15:24 2026"
* Vendor:   "Siemens"
* Program:  "Calibre xRC"
* Version:  "v2025.3_28.17"

*
.subckt AND601 IN3 IN2 IN1 IN6 IN5 IN4 OUT1 VDD VSS
*
*
*

M0 VDD IN3 8 VDD P L=1.5e-06 W=1.15e-05 AD=4.485e-11 AS=4.3125e-11 PD=3.08e-05
+ PS=3.05e-05 NRD=0.169565 NRS=0.173913
M1 8 IN2 VDD VDD P L=1.5e-06 W=1.15e-05 AD=4.485e-11 AS=4.485e-11 PD=3.08e-05
+ PS=3.08e-05 NRD=0.169565 NRS=0.169565
M2 VDD IN1 8 VDD P L=1.5e-06 W=1.15e-05 AD=4.485e-11 AS=4.485e-11 PD=3.08e-05
+ PS=3.08e-05 NRD=0.169565 NRS=0.169565
M3 9 IN6 VDD VDD P L=1.5e-06 W=1.15e-05 AD=4.485e-11 AS=4.485e-11 PD=3.08e-05
+ PS=3.08e-05 NRD=0.169565 NRS=0.169565
M4 VDD IN5 9 VDD P L=1.5e-06 W=1.15e-05 AD=4.485e-11 AS=4.485e-11 PD=3.08e-05
+ PS=3.08e-05 NRD=0.169565 NRS=0.169565
M5 9 IN4 VDD VDD P L=1.5e-06 W=1.15e-05 AD=4.7725e-11 AS=4.485e-11 PD=3.13e-05
+ PS=3.08e-05 NRD=0.169565 NRS=0.169565
M6 27 8 VDD VDD P L=1.5e-06 W=1.3e-05 AD=1.3e-11 AS=4.81e-11 PD=1.5e-05
+ PS=3.34e-05 NRD=0.0769231 NRS=0.15
M7 10 9 27 VDD P L=1.5e-06 W=1.3e-05 AD=4.81e-11 AS=1.3e-11 PD=3.34e-05
+ PS=1.5e-05 NRD=0.15 NRS=0.0769231
M8 VDD 10 11 VDD P L=1.5e-06 W=1.1e-05 AD=5.2e-11 AS=4.07e-11 PD=3.8e-05
+ PS=2.94e-05 NRD=0.177273 NRS=0.177273
M9 OUT1 11 VDD VDD P L=1.5e-06 W=1.5e-05 AD=5.55e-11 AS=5.2e-11 PD=3.74e-05
+ PS=3.8e-05 NRD=0.13 NRS=0.136667
M10 28 IN3 VSS VSS N L=1.2e-06 W=6.5e-06 AD=6.5e-12 AS=2.405e-11 PD=8.5e-06
+ PS=2.04e-05 NRD=0.153846 NRS=0.3
M11 29 IN2 28 VSS N L=1.2e-06 W=6.5e-06 AD=7.475e-12 AS=6.5e-12 PD=8.8e-06
+ PS=8.5e-06 NRD=0.176923 NRS=0.153846
M12 8 IN1 29 VSS N L=1.2e-06 W=6.5e-06 AD=2.405e-11 AS=7.475e-12 PD=2.04e-05
+ PS=8.8e-06 NRD=0.3 NRS=0.176923
M13 30 IN6 VSS VSS N L=1.2e-06 W=6.5e-06 AD=6.5e-12 AS=2.405e-11 PD=8.5e-06
+ PS=2.04e-05 NRD=0.153846 NRS=0.3
M14 31 IN5 30 VSS N L=1.2e-06 W=6.5e-06 AD=6.5e-12 AS=6.5e-12 PD=8.5e-06
+ PS=8.5e-06 NRD=0.153846 NRS=0.153846
M15 9 IN4 31 VSS N L=1.2e-06 W=6.5e-06 AD=2.405e-11 AS=6.5e-12 PD=2.04e-05
+ PS=8.5e-06 NRD=0.3 NRS=0.153846
M16 10 8 VSS VSS N L=1.2e-06 W=7e-06 AD=2.94e-11 AS=2.59e-11 PD=2.24e-05
+ PS=2.14e-05 NRD=0.278571 NRS=0.278571
M17 VSS 9 10 VSS N L=1.2e-06 W=7e-06 AD=2.59e-11 AS=2.94e-11 PD=2.14e-05
+ PS=2.24e-05 NRD=0.278571 NRS=0.321429
M18 VSS 10 11 VSS N L=1.2e-06 W=6e-06 AD=2.6475e-11 AS=2.25e-11 PD=2.28e-05
+ PS=1.95e-05 NRD=0.325 NRS=0.333333
M19 OUT1 11 VSS VSS N L=1.2e-06 W=7.5e-06 AD=2.775e-11 AS=2.6475e-11
+ PD=2.24e-05 PS=2.28e-05 NRD=0.26 NRS=0.26

.ends
*
* Design:   AND701
* Created:  "Fri Apr 10 20:23:33 2026"
* Vendor:   "Siemens"
* Program:  "Calibre xRC"
* Version:  "v2025.3_28.17"

*
.subckt AND701 IN5 IN6 IN7 IN4 IN3 IN2 IN1 OUT1 VDD VSS
*
*
*

M0 VDD IN5 9 VDD P L=1.5e-06 W=1.3e-05 AD=5.07e-11 AS=4.81e-11 PD=3.38e-05
+ PS=3.34e-05 NRD=0.15 NRS=0.15
M1 9 IN6 VDD VDD P L=1.5e-06 W=1.3e-05 AD=5.07e-11 AS=5.07e-11 PD=3.38e-05
+ PS=3.38e-05 NRD=0.15 NRS=0.15
M2 VDD IN7 9 VDD P L=1.5e-06 W=1.3e-05 AD=5.67e-11 AS=5.07e-11 PD=3.98e-05
+ PS=3.38e-05 NRD=0.15 NRS=0.15
M3 10 IN4 VDD VDD P L=1.5e-06 W=1.6e-05 AD=6.24e-11 AS=5.67e-11 PD=3.98e-05
+ PS=3.98e-05 NRD=0.121875 NRS=0.121875
M4 VDD IN3 10 VDD P L=1.5e-06 W=1.6e-05 AD=6.24e-11 AS=6.24e-11 PD=3.98e-05
+ PS=3.98e-05 NRD=0.121875 NRS=0.121875
M5 10 IN2 VDD VDD P L=1.5e-06 W=1.6e-05 AD=7.2e-11 AS=6.24e-11 PD=4.1e-05
+ PS=3.98e-05 NRD=0.121875 NRS=0.121875
M6 VDD IN1 10 VDD P L=1.5e-06 W=1.6e-05 AD=5.5e-11 AS=7.2e-11 PD=3.98e-05
+ PS=4.1e-05 NRD=0.121875 NRS=0.159375
M7 28 9 VDD VDD P L=1.5e-06 W=1.2e-05 AD=1.2e-11 AS=5.5e-11 PD=1.4e-05
+ PS=3.98e-05 NRD=0.0833333 NRS=0.1625
M8 11 10 28 VDD P L=1.5e-06 W=1.2e-05 AD=4.44e-11 AS=1.2e-11 PD=3.14e-05
+ PS=1.4e-05 NRD=0.1625 NRS=0.0833333
M9 VDD 11 14 VDD P L=1.5e-06 W=1.3e-05 AD=8.509e-11 AS=4.81e-11 PD=5.62e-05
+ PS=3.34e-05 NRD=0.15 NRS=0.15
M10 OUT1 14 VDD VDD P L=1.5e-06 W=1.9e-05 AD=6.25e-11 AS=8.509e-11 PD=3.5e-05
+ PS=5.62e-05 NRD=0.139474 NRS=0.102632
M11 29 IN5 9 VSS N L=1.2e-06 W=8e-06 AD=1e-11 AS=2.96e-11 PD=1.05e-05
+ PS=2.34e-05 NRD=0.15625 NRS=0.24375
M12 30 IN6 29 VSS N L=1.2e-06 W=8e-06 AD=1e-11 AS=1e-11 PD=1.05e-05 PS=1.05e-05
+ NRD=0.15625 NRS=0.15625
M13 VSS IN7 30 VSS N L=1.2e-06 W=8e-06 AD=2.96e-11 AS=1e-11 PD=2.34e-05
+ PS=1.05e-05 NRD=0.24375 NRS=0.15625
M14 31 IN4 VSS VSS N L=1.2e-06 W=1e-05 AD=1e-11 AS=3.85e-11 PD=1.2e-05
+ PS=2.77e-05 NRD=0.1 NRS=0.21
M15 32 IN3 31 VSS N L=1.2e-06 W=1e-05 AD=1e-11 AS=1e-11 PD=1.2e-05 PS=1.2e-05
+ NRD=0.1 NRS=0.1
M16 33 IN2 32 VSS N L=1.2e-06 W=1e-05 AD=1.41722e-11 AS=1e-11 PD=1.59434e-05
+ PS=1.2e-05 NRD=0.345 NRS=0.1
M17 10 IN1 33 VSS N L=1.2e-06 W=1e-05 AD=1.887e-11 AS=1.41722e-11 PD=1.76e-05
+ PS=1.59434e-05 NRD=0.265 NRS=0.285
M18 11 9 VSS VSS N L=1.2e-06 W=7e-06 AD=2.73e-11 AS=2.59e-11 PD=2.18e-05
+ PS=2.14e-05 NRD=0.278571 NRS=0.278571
M19 VSS 10 11 VSS N L=1.2e-06 W=7e-06 AD=2.59e-11 AS=2.73e-11 PD=2.14e-05
+ PS=2.18e-05 NRD=0.278571 NRS=0.278571
M20 VSS 11 14 VSS N L=1.2e-06 W=7e-06 AD=4.943e-11 AS=2.59e-11 PD=3.56e-05
+ PS=2.14e-05 NRD=0.390476 NRS=0.278571
M21 OUT1 14 VSS VSS N L=1.2e-06 W=9e-06 AD=1.517e-11 AS=4.943e-11 PD=1.56e-05
+ PS=3.56e-05 NRD=0.238889 NRS=0.241228

.ends
*
* Design:   AND801
* Created:  "Fri Apr 10 20:27:24 2026"
* Vendor:   "Siemens"
* Program:  "Calibre xRC"
* Version:  "v2025.3_28.17"

*
.subckt AND801 IN1 IN2 IN3 IN4 IN8 IN7 IN6 IN5 OUT1 VDD VSS
*
*
*

M0 10 IN1 VDD VDD P L=1.5e-06 W=1.3e-05 AD=5.07e-11 AS=4.81e-11 PD=3.38e-05
+ PS=3.34e-05 NRD=0.15 NRS=0.15
M1 VDD IN2 10 VDD P L=1.5e-06 W=1.3e-05 AD=5.07e-11 AS=5.07e-11 PD=3.38e-05
+ PS=3.38e-05 NRD=0.15 NRS=0.15
M2 10 IN3 VDD VDD P L=1.5e-06 W=1.3e-05 AD=5.07e-11 AS=5.07e-11 PD=3.38e-05
+ PS=3.38e-05 NRD=0.15 NRS=0.15
M3 VDD IN4 10 VDD P L=1.5e-06 W=1.3e-05 AD=5.07e-11 AS=5.07e-11 PD=3.38e-05
+ PS=3.38e-05 NRD=0.15 NRS=0.15
M4 11 IN8 VDD VDD P L=1.5e-06 W=1.3e-05 AD=5.07e-11 AS=5.07e-11 PD=3.38e-05
+ PS=3.38e-05 NRD=0.15 NRS=0.15
M5 VDD IN7 11 VDD P L=1.5e-06 W=1.3e-05 AD=5.07e-11 AS=5.07e-11 PD=3.38e-05
+ PS=3.38e-05 NRD=0.15 NRS=0.15
M6 11 IN6 VDD VDD P L=1.5e-06 W=1.3e-05 AD=5.07e-11 AS=5.07e-11 PD=3.38e-05
+ PS=3.38e-05 NRD=0.15 NRS=0.15
M7 VDD IN5 11 VDD P L=1.5e-06 W=1.3e-05 AD=5.4e-11 AS=5.07e-11 PD=3.6e-05
+ PS=3.38e-05 NRD=0.15 NRS=0.15
M8 28 10 VDD VDD P L=1.5e-06 W=1.4e-05 AD=1.365e-11 AS=5.4e-11 PD=1.595e-05
+ PS=3.6e-05 NRD=0.0696429 NRS=0.146429
M9 12 11 28 VDD P L=1.5e-06 W=1.4e-05 AD=5.18e-11 AS=1.365e-11 PD=3.54e-05
+ PS=1.595e-05 NRD=0.139286 NRS=0.0696429
M10 VDD 12 13 VDD P L=1.5e-06 W=1.1e-05 AD=5.145e-11 AS=4.07e-11 PD=3.79e-05
+ PS=2.94e-05 NRD=0.177273 NRS=0.177273
M11 OUT1 13 VDD VDD P L=1.5e-06 W=1.5e-05 AD=5.55e-11 AS=5.145e-11 PD=3.74e-05
+ PS=3.79e-05 NRD=0.13 NRS=0.133333
M12 29 IN1 10 VSS N L=1.2e-06 W=8e-06 AD=8e-12 AS=2.96e-11 PD=1e-05 PS=2.34e-05
+ NRD=0.125 NRS=0.24375
M13 30 IN2 29 VSS N L=1.2e-06 W=8e-06 AD=8e-12 AS=8e-12 PD=1e-05 PS=1e-05
+ NRD=0.125 NRS=0.125
M14 31 IN3 30 VSS N L=1.2e-06 W=8e-06 AD=8e-12 AS=8e-12 PD=1e-05 PS=1e-05
+ NRD=0.125 NRS=0.125
M15 VSS IN4 31 VSS N L=1.2e-06 W=8e-06 AD=3e-11 AS=8e-12 PD=2.35e-05 PS=1e-05
+ NRD=0.24375 NRS=0.125
M16 32 IN8 VSS VSS N L=1.2e-06 W=8e-06 AD=8e-12 AS=2.96e-11 PD=1e-05
+ PS=2.34e-05 NRD=0.125 NRS=0.24375
M17 33 IN7 32 VSS N L=1.2e-06 W=8e-06 AD=1.36e-11 AS=8e-12 PD=1.14e-05 PS=1e-05
+ NRD=0.2125 NRS=0.125
M18 34 IN6 33 VSS N L=1.2e-06 W=8e-06 AD=8e-12 AS=1.36e-11 PD=1e-05 PS=1.14e-05
+ NRD=0.125 NRS=0.2125
M19 11 IN5 34 VSS N L=1.2e-06 W=8e-06 AD=3e-11 AS=8e-12 PD=2.35e-05 PS=1e-05
+ NRD=0.25 NRS=0.125
M20 12 10 VSS VSS N L=1.2e-06 W=7e-06 AD=2.765e-11 AS=2.59e-11 PD=2.19e-05
+ PS=2.14e-05 NRD=0.278571 NRS=0.278571
M21 VSS 11 12 VSS N L=1.2e-06 W=7e-06 AD=2.59e-11 AS=2.765e-11 PD=2.14e-05
+ PS=2.19e-05 NRD=0.278571 NRS=0.285714
M22 VSS 12 13 VSS N L=1.2e-06 W=6e-06 AD=2.715e-11 AS=2.22e-11 PD=2.3e-05
+ PS=1.94e-05 NRD=0.325 NRS=0.325
M23 OUT1 13 VSS VSS N L=1.2e-06 W=7.5e-06 AD=2.775e-11 AS=2.715e-11 PD=2.24e-05
+ PS=2.3e-05 NRD=0.26 NRS=0.273333

.ends
*
* Design:   AOI401
* Created:  "Fri Apr 10 20:28:18 2026"
* Vendor:   "Siemens"
* Program:  "Calibre xRC"
* Version:  "v2025.3_28.17"

*
.subckt AOI401 A B C D OUT1 VDD VSS
*
*
*

M0 VDD A 8 VDD P L=1.5e-06 W=1e-05 AD=3.9e-11 AS=3.7e-11 PD=2.78e-05
+ PS=2.74e-05 NRD=0.195 NRS=0.195
M1 8 B VDD VDD P L=1.5e-06 W=1e-05 AD=3.9e-11 AS=3.9e-11 PD=2.78e-05
+ PS=2.78e-05 NRD=0.195 NRS=0.195
M2 4 C 8 VDD P L=1.5e-06 W=1e-05 AD=3.9e-11 AS=3.9e-11 PD=2.78e-05 PS=2.78e-05
+ NRD=0.195 NRS=0.195
M3 8 D 4 VDD P L=1.5e-06 W=1e-05 AD=3.85e-11 AS=3.9e-11 PD=2.77e-05 PS=2.78e-05
+ NRD=0.195 NRS=0.195
M4 VDD 4 6 VDD P L=1.5e-06 W=1e-05 AD=7.974e-11 AS=3.7e-11 PD=4.88e-05
+ PS=2.74e-05 NRD=0.195 NRS=0.195
M5 OUT1 6 VDD VDD P L=1.5e-06 W=1.5e-05 AD=3.626e-11 AS=7.974e-11 PD=2.7e-05
+ PS=4.88e-05 NRD=0.131667 NRS=0.159524
M6 17 A VSS VSS N L=1.2e-06 W=9e-06 AD=9e-12 AS=3.33e-11 PD=1.1e-05 PS=2.54e-05
+ NRD=0.111111 NRS=0.216667
M7 4 B 17 VSS N L=1.2e-06 W=9e-06 AD=3.33e-11 AS=9e-12 PD=2.54e-05 PS=1.1e-05
+ NRD=0.216667 NRS=0.111111
M8 18 C 4 VSS N L=1.2e-06 W=9e-06 AD=9e-12 AS=3.33e-11 PD=1.1e-05 PS=2.54e-05
+ NRD=0.111111 NRS=0.216667
M9 VSS D 18 VSS N L=1.2e-06 W=9e-06 AD=3.33e-11 AS=9e-12 PD=2.54e-05 PS=1.1e-05
+ NRD=0.216667 NRS=0.111111
M10 VSS 4 6 VSS N L=1.2e-06 W=9e-06 AD=3.86e-11 AS=3.33e-11 PD=2.68e-05
+ PS=2.54e-05 NRD=0.216667 NRS=0.216667
M11 OUT1 6 VSS VSS N L=1.2e-06 W=7e-06 AD=2.625e-11 AS=3.86e-11 PD=2.15e-05
+ PS=2.68e-05 NRD=0.278571 NRS=0.35

.ends
*
* Design:   CDRI01
* Created:  "Fri Apr 10 20:29:14 2026"
* Vendor:   "Siemens"
* Program:  "Calibre xRC"
* Version:  "v2025.3_28.17"

*

.subckt CDRI01 IN1 Q  VDD VSS
*
*
*

M0 VDD IN1 QB VDD P L=1.5e-06 W=1.5e-05 AD=5.85e-11 AS=5.625e-11 PD=3.78e-05
+ PS=3.75e-05 NRD=0.13 NRS=0.133333
M1 QB IN1 VDD VDD P L=1.5e-06 W=1.5e-05 AD=5.85e-11 AS=5.85e-11 PD=3.78e-05
+ PS=3.78e-05 NRD=0.13 NRS=0.13
M2 VDD IN1 QB VDD P L=1.5e-06 W=1.5e-05 AD=5.85e-11 AS=5.85e-11 PD=3.78e-05
+ PS=3.78e-05 NRD=0.13 NRS=0.13
M3 QB IN1 VDD VDD P L=1.5e-06 W=1.5e-05 AD=5.55e-11 AS=5.85e-11 PD=3.74e-05
+ PS=3.78e-05 NRD=0.13 NRS=0.13
M4 VDD QB Q VDD P L=1.5e-06 W=1.25e-05 AD=4.875e-11 AS=4.6875e-11 PD=3.28e-05
+ PS=3.25e-05 NRD=0.156 NRS=0.16
M5 Q QB VDD VDD P L=1.5e-06 W=1.25e-05 AD=4.875e-11 AS=4.875e-11 PD=3.28e-05
+ PS=3.28e-05 NRD=0.156 NRS=0.156
M6 VDD QB Q VDD P L=1.5e-06 W=1.25e-05 AD=4.875e-11 AS=4.875e-11 PD=3.28e-05
+ PS=3.28e-05 NRD=0.156 NRS=0.156
M7 Q QB VDD VDD P L=1.5e-06 W=1.25e-05 AD=4.625e-11 AS=4.875e-11 PD=3.24e-05
+ PS=3.28e-05 NRD=0.156 NRS=0.156
M8 VSS IN1 QB VSS N L=1.2e-06 W=7.5e-06 AD=2.925e-11 AS=2.775e-11 PD=2.28e-05
+ PS=2.24e-05 NRD=0.26 NRS=0.26
M9 QB IN1 VSS VSS N L=1.2e-06 W=7.5e-06 AD=2.925e-11 AS=2.925e-11 PD=2.28e-05
+ PS=2.28e-05 NRD=0.26 NRS=0.26
M10 VSS IN1 QB VSS N L=1.2e-06 W=7.5e-06 AD=2.925e-11 AS=2.925e-11 PD=2.28e-05
+ PS=2.28e-05 NRD=0.26 NRS=0.26
M11 QB IN1 VSS VSS N L=1.2e-06 W=7.5e-06 AD=2.775e-11 AS=2.925e-11 PD=2.24e-05
+ PS=2.28e-05 NRD=0.26 NRS=0.26
M12 VSS QB Q VSS N L=1.2e-06 W=6.25e-06 AD=2.4375e-11 AS=2.3125e-11 PD=2.03e-05
+ PS=1.99e-05 NRD=0.312 NRS=0.312
M13 Q QB VSS VSS N L=1.2e-06 W=6.25e-06 AD=2.4375e-11 AS=2.4375e-11 PD=2.03e-05
+ PS=2.03e-05 NRD=0.312 NRS=0.312
M14 VSS QB Q VSS N L=1.2e-06 W=6.25e-06 AD=2.4375e-11 AS=2.4375e-11 PD=2.03e-05
+ PS=2.03e-05 NRD=0.312 NRS=0.312
M15 Q QB VSS VSS N L=1.2e-06 W=6.25e-06 AD=2.3125e-11 AS=2.4375e-11 PD=1.99e-05
+ PS=2.03e-05 NRD=0.312 NRS=0.312

.ends
*
* Design:   CDRI02
* Created:  "Fri Apr 10 20:30:26 2026"
* Vendor:   "Siemens"
* Program:  "Calibre xRC"
* Version:  "v2025.3_28.17"

*
.subckt CDRI02 IN1 QB Q VDD VSS
*
*
*

M0 VDD IN1 QB VDD P L=1.5e-06 W=1.875e-05 AD=7.3125e-11 AS=7.03125e-11
+ PD=4.53e-05 PS=4.5e-05 NRD=0.104 NRS=0.106667
M1 QB IN1 VDD VDD P L=1.5e-06 W=1.875e-05 AD=7.3125e-11 AS=7.3125e-11
+ PD=4.53e-05 PS=4.53e-05 NRD=0.104 NRS=0.104
M2 VDD IN1 QB VDD P L=1.5e-06 W=1.875e-05 AD=7.3125e-11 AS=7.3125e-11
+ PD=4.53e-05 PS=4.53e-05 NRD=0.104 NRS=0.104
M3 QB IN1 VDD VDD P L=1.5e-06 W=1.875e-05 AD=6.9375e-11 AS=7.3125e-11
+ PD=4.49e-05 PS=4.53e-05 NRD=0.104 NRS=0.104
M4 VDD QB Q VDD P L=1.5e-06 W=1.875e-05 AD=7.3125e-11 AS=7.03125e-11
+ PD=4.53e-05 PS=4.5e-05 NRD=0.104 NRS=0.106667
M5 Q QB VDD VDD P L=1.5e-06 W=1.875e-05 AD=7.3125e-11 AS=7.3125e-11 PD=4.53e-05
+ PS=4.53e-05 NRD=0.104 NRS=0.104
M6 VDD QB Q VDD P L=1.5e-06 W=1.875e-05 AD=7.3125e-11 AS=7.3125e-11 PD=4.53e-05
+ PS=4.53e-05 NRD=0.104 NRS=0.104
M7 Q QB VDD VDD P L=1.5e-06 W=1.875e-05 AD=6.9375e-11 AS=7.3125e-11 PD=4.49e-05
+ PS=4.53e-05 NRD=0.104 NRS=0.104
M8 VSS IN1 QB VSS N L=1.2e-06 W=8.75e-06 AD=3.4125e-11 AS=3.2375e-11
+ PD=2.53e-05 PS=2.49e-05 NRD=0.222857 NRS=0.222857
M9 QB IN1 VSS VSS N L=1.2e-06 W=8.75e-06 AD=3.4125e-11 AS=3.4125e-11
+ PD=2.53e-05 PS=2.53e-05 NRD=0.222857 NRS=0.222857
M10 VSS IN1 QB VSS N L=1.2e-06 W=8.75e-06 AD=3.4125e-11 AS=3.4125e-11
+ PD=2.53e-05 PS=2.53e-05 NRD=0.222857 NRS=0.222857
M11 QB IN1 VSS VSS N L=1.2e-06 W=8.75e-06 AD=3.2375e-11 AS=3.4125e-11
+ PD=2.49e-05 PS=2.53e-05 NRD=0.222857 NRS=0.222857
M12 VSS QB Q VSS N L=1.2e-06 W=1.125e-05 AD=4.3875e-11 AS=4.1625e-11
+ PD=3.03e-05 PS=2.99e-05 NRD=0.173333 NRS=0.173333
M13 Q QB VSS VSS N L=1.2e-06 W=1.125e-05 AD=4.3875e-11 AS=4.3875e-11
+ PD=3.03e-05 PS=3.03e-05 NRD=0.173333 NRS=0.173333
M14 VSS QB Q VSS N L=1.2e-06 W=1.125e-05 AD=4.3875e-11 AS=4.3875e-11
+ PD=3.03e-05 PS=3.03e-05 NRD=0.173333 NRS=0.173333
M15 Q QB VSS VSS N L=1.2e-06 W=1.125e-05 AD=4.1625e-11 AS=4.3875e-11
+ PD=2.99e-05 PS=3.03e-05 NRD=0.173333 NRS=0.173333

.ends
*
* Design:   DEC24H
* Created:  "Fri Apr 17 14:58:35 2026"
* Vendor:   "Siemens"
* Program:  "Calibre xRC"
* Version:  "v2025.3_28.17"

*
.subckt DEC24H Q2 A1 Q1 EN A2 Q3 Q4 VDD VSS
*
*
*

M0 Q2 12 VDD VDD P L=1.5e-06 W=1.6e-05 AD=4.2765e-11 AS=8.344e-11 PD=3.12e-05
+ PS=5.08e-05 NRD=0.134375 NRS=0.135691
M1 12 EN VDD VDD P L=1.5e-06 W=1e-05 AD=3.9e-11 AS=8.344e-11 PD=2.78e-05
+ PS=5.08e-05 NRD=0.195 NRS=0.217241
M2 VDD A1 12 VDD P L=1.5e-06 W=1e-05 AD=3.9e-11 AS=3.9e-11 PD=2.78e-05
+ PS=2.78e-05 NRD=0.195 NRS=0.195
M3 12 6 VDD VDD P L=1.5e-06 W=1e-05 AD=3.7e-11 AS=3.9e-11 PD=2.74e-05
+ PS=2.78e-05 NRD=0.195 NRS=0.195
M4 VDD 4 Q1 VDD P L=1.5e-06 W=1.57e-05 AD=8.233e-11 AS=3.885e-11 PD=5.02e-05
+ PS=2.84e-05 NRD=0.124204 NRS=0.191083
M5 4 EN VDD VDD P L=1.5e-06 W=1e-05 AD=4.07024e-11 AS=8.233e-11 PD=2.87548e-05
+ PS=5.02e-05 NRD=0.195 NRS=0.233654
M6 VDD 7 4 VDD P L=1.5e-06 W=1.02548e-05 AD=3.73094e-11 AS=4.07024e-11
+ PD=2.76548e-05 PS=2.87548e-05 NRD=0.190154 NRS=0.253432
M7 4 6 VDD VDD P L=1.5e-06 W=1.015e-05 AD=3.7555e-11 AS=3.73094e-11 PD=2.77e-05
+ PS=2.76548e-05 NRD=0.192118 NRS=0.192118
M8 6 A2 VDD VDD P L=1.5e-06 W=1.76e-05 AD=5.004e-11 AS=1.0992e-10 PD=3.22e-05
+ PS=6.51e-05 NRD=0.201705 NRS=0.110795
M9 7 A1 VDD VDD P L=1.5e-06 W=1.7e-05 AD=4.816e-11 AS=1.0992e-10 PD=3.1e-05
+ PS=6.51e-05 NRD=0.15 NRS=0.116667
M10 VDD A2 9 VDD P L=1.5e-06 W=1.02e-05 AD=3.74454e-11 AS=3.774e-11
+ PD=2.77548e-05 PS=2.78e-05 NRD=0.191176 NRS=0.191176
M11 9 7 VDD VDD P L=1.5e-06 W=1.02548e-05 AD=4.06926e-11 AS=3.74454e-11
+ PD=2.87548e-05 PS=2.77548e-05 NRD=0.224285 NRS=0.190154
M12 VDD EN 9 VDD P L=1.5e-06 W=1e-05 AD=8.233e-11 AS=4.06926e-11 PD=5.02e-05
+ PS=2.87548e-05 NRD=0.2125 NRS=0.195
M13 Q3 9 VDD VDD P L=1.5e-06 W=1.57e-05 AD=3.885e-11 AS=8.233e-11 PD=2.84e-05
+ PS=5.02e-05 NRD=0.187898 NRS=0.126839
M14 VDD A2 13 VDD P L=1.5e-06 W=1e-05 AD=3.9e-11 AS=3.7e-11 PD=2.78e-05
+ PS=2.74e-05 NRD=0.195 NRS=0.195
M15 13 A1 VDD VDD P L=1.5e-06 W=1e-05 AD=3.9e-11 AS=3.9e-11 PD=2.78e-05
+ PS=2.78e-05 NRD=0.195 NRS=0.195
M16 VDD EN 13 VDD P L=1.5e-06 W=1e-05 AD=8.344e-11 AS=3.9e-11 PD=5.08e-05
+ PS=2.78e-05 NRD=0.225 NRS=0.195
M17 Q4 13 VDD VDD P L=1.5e-06 W=1.6e-05 AD=4.2765e-11 AS=8.344e-11 PD=3.12e-05
+ PS=5.08e-05 NRD=0.134375 NRS=0.133413
M18 VSS 12 Q2 VSS N L=1.2e-06 W=8e-06 AD=5.146e-11 AS=1.499e-11 PD=3.68e-05
+ PS=1.58e-05 NRD=0.31875 NRS=0.226103
M19 37 EN VSS VSS N L=1.2e-06 W=8e-06 AD=8e-12 AS=5.146e-11 PD=1e-05
+ PS=3.68e-05 NRD=0.125 NRS=0.211287
M20 38 A1 37 VSS N L=1.2e-06 W=8e-06 AD=8e-12 AS=8e-12 PD=1e-05 PS=1e-05
+ NRD=0.125 NRS=0.125
M21 12 6 38 VSS N L=1.2e-06 W=8e-06 AD=2.96e-11 AS=8e-12 PD=2.34e-05 PS=1e-05
+ NRD=0.24375 NRS=0.125
M22 VSS 4 Q1 VSS N L=1.2e-06 W=8.05e-06 AD=5.024e-11 AS=1.52e-11 PD=3.55e-05
+ PS=1.59e-05 NRD=0.31677 NRS=0.222792
M23 39 EN VSS VSS N L=1.2e-06 W=8e-06 AD=1.64e-11 AS=5.024e-11 PD=1.21e-05
+ PS=3.55e-05 NRD=0.25625 NRS=0.266447
M24 40 7 39 VSS N L=1.2e-06 W=8e-06 AD=7.2e-12 AS=1.64e-11 PD=9.8e-06
+ PS=1.21e-05 NRD=0.1125 NRS=0.25625
M25 4 6 40 VSS N L=1.2e-06 W=8e-06 AD=2.96e-11 AS=7.2e-12 PD=2.34e-05
+ PS=9.8e-06 NRD=0.24375 NRS=0.1125
M26 6 A2 VSS VSS N L=1.2e-06 W=7e-06 AD=2.59e-11 AS=2.59e-11 PD=2.14e-05
+ PS=2.14e-05 NRD=0.278571 NRS=0.278571
M27 7 A1 VSS VSS N L=1.2e-06 W=7e-06 AD=2.94e-11 AS=2.59e-11 PD=2.24e-05
+ PS=2.14e-05 NRD=0.278571 NRS=0.278571
M28 41 A2 9 VSS N L=1.2e-06 W=8e-06 AD=8e-12 AS=2.96e-11 PD=1e-05 PS=2.34e-05
+ NRD=0.125 NRS=0.24375
M29 42 7 41 VSS N L=1.2e-06 W=8e-06 AD=1.64e-11 AS=8e-12 PD=1.21e-05 PS=1e-05
+ NRD=0.25625 NRS=0.125
M30 VSS EN 42 VSS N L=1.2e-06 W=8e-06 AD=4.92425e-11 AS=1.64e-11 PD=3.5e-05
+ PS=1.21e-05 NRD=0.327083 NRS=0.25625
M31 Q3 9 VSS VSS N L=1.2e-06 W=8.05e-06 AD=1.5015e-11 AS=4.92425e-11
+ PD=1.58e-05 PS=3.5e-05 NRD=0.242236 NRS=0.274467
M32 43 A2 13 VSS N L=1.2e-06 W=8e-06 AD=8e-12 AS=2.96e-11 PD=1e-05 PS=2.34e-05
+ NRD=0.125 NRS=0.24375
M33 44 A1 43 VSS N L=1.2e-06 W=8e-06 AD=8e-12 AS=8e-12 PD=1e-05 PS=1e-05
+ NRD=0.125 NRS=0.125
M34 VSS EN 44 VSS N L=1.2e-06 W=8e-06 AD=4.972e-11 AS=8e-12 PD=3.48e-05
+ PS=1e-05 NRD=0.3625 NRS=0.125
M35 Q4 13 VSS VSS N L=1.2e-06 W=8e-06 AD=1.499e-11 AS=4.972e-11 PD=1.58e-05
+ PS=3.48e-05 NRD=0.24375 NRS=0.278682

.ends
*
* Design:   DEC24L
* Created:  "Thu Apr 16 17:26:36 2026"
* Vendor:   "Siemens"
* Program:  "Calibre xRC"
* Version:  "v2025.3_28.17"

*
.subckt DEC24L Q1 EN Q3 A2 Q4 A1 Q2 VSS VDD
*
*
*

M0 VDD 6 Q1 VDD P L=1.5e-06 W=1.6e-05 AD=8.252e-11 AS=4.7635e-11 PD=5.04e-05
+ PS=3.08e-05 NRD=0.126562 NRS=0.160417
M1 Q1 5 VDD VDD P L=1.5e-06 W=1.5e-05 AD=5.85e-11 AS=8.252e-11 PD=3.78e-05
+ PS=5.04e-05 NRD=0.21 NRS=0.122093
M2 VDD EN Q1 VDD P L=1.5e-06 W=1.5e-05 AD=5.85e-11 AS=5.85e-11 PD=3.78e-05
+ PS=3.78e-05 NRD=0.13 NRS=0.13
M3 Q3 EN VDD VDD P L=1.5e-06 W=1.5e-05 AD=5.85e-11 AS=5.85e-11 PD=3.78e-05
+ PS=3.78e-05 NRD=0.13 NRS=0.13
M4 VDD 5 Q3 VDD P L=1.5e-06 W=1.5e-05 AD=7.9e-11 AS=5.85e-11 PD=4.84e-05
+ PS=3.78e-05 NRD=0.135 NRS=0.13
M5 Q3 A2 VDD VDD P L=1.5e-06 W=1.5e-05 AD=3.98e-11 AS=7.9e-11 PD=2.94e-05
+ PS=4.84e-05 NRD=0.154444 NRS=0.135
M6 VDD A1 5 VDD P L=1.5e-06 W=1.6e-05 AD=9.823e-11 AS=4.35675e-11 PD=5.87e-05
+ PS=3.11e-05 NRD=0.140625 NRS=0.137868
M7 6 A2 VDD VDD P L=1.5e-06 W=1.6e-05 AD=4.586e-11 AS=9.823e-11 PD=3.15e-05
+ PS=5.87e-05 NRD=0.146875 NRS=0.127047
M8 Q4 A2 VDD VDD P L=1.5e-06 W=1.5e-05 AD=4.16575e-11 AS=7.887e-11 PD=3.06e-05
+ PS=4.84e-05 NRD=0.153333 NRS=0.135
M9 Q4 A1 VDD VDD P L=1.5e-06 W=1.5e-05 AD=5.85e-11 AS=7.887e-11 PD=3.78e-05
+ PS=4.84e-05 NRD=0.13 NRS=0.1475
M10 VDD EN Q4 VDD P L=1.5e-06 W=1.5e-05 AD=5.982e-11 AS=5.85e-11 PD=3.89e-05
+ PS=3.78e-05 NRD=0.13 NRS=0.13
M11 Q2 EN VDD VDD P L=1.5e-06 W=1.555e-05 AD=6.0645e-11 AS=5.982e-11
+ PD=3.89e-05 PS=3.89e-05 NRD=0.125402 NRS=0.125402
M12 VDD A1 Q2 VDD P L=1.5e-06 W=1.555e-05 AD=7.82875e-11 AS=6.0645e-11
+ PD=4.87e-05 PS=3.89e-05 NRD=0.142283 NRS=0.125402
M13 Q2 6 VDD VDD P L=1.5e-06 W=1.525e-05 AD=4.1525e-11 AS=7.82875e-11
+ PD=2.97e-05 PS=4.87e-05 NRD=0.174863 NRS=0.127869
M14 28 6 Q1 VSS N L=1.2e-06 W=1.2e-05 AD=1.74e-11 AS=5.64e-11 PD=1.49e-05
+ PS=3.34e-05 NRD=0.120833 NRS=0.1625
M15 29 5 28 VSS N L=1.2e-06 W=1.2e-05 AD=1.32e-11 AS=1.74e-11 PD=1.42e-05
+ PS=1.49e-05 NRD=0.0916667 NRS=0.120833
M16 VSS EN 29 VSS N L=1.2e-06 W=1.2e-05 AD=1.164e-10 AS=1.32e-11 PD=4.34e-05
+ PS=1.42e-05 NRD=0.7125 NRS=0.0916667
M17 30 EN VSS VSS N L=1.2e-06 W=1.2e-05 AD=1.32e-11 AS=1.164e-10 PD=1.42e-05
+ PS=4.34e-05 NRD=0.0916667 NRS=0.432753
M18 31 5 30 VSS N L=1.2e-06 W=1.2e-05 AD=2.34e-11 AS=1.32e-11 PD=1.59e-05
+ PS=1.42e-05 NRD=0.1625 NRS=0.0916667
M19 Q3 A2 31 VSS N L=1.2e-06 W=1.2e-05 AD=4.44e-11 AS=2.34e-11 PD=3.14e-05
+ PS=1.59e-05 NRD=0.1625 NRS=0.1625
M20 VSS A1 5 VSS N L=1.2e-06 W=7e-06 AD=2.73e-11 AS=2.59e-11 PD=2.18e-05
+ PS=2.14e-05 NRD=0.278571 NRS=0.278571
M21 6 A2 VSS VSS N L=1.2e-06 W=7e-06 AD=2.94e-11 AS=2.73e-11 PD=2.24e-05
+ PS=2.18e-05 NRD=0.278571 NRS=0.278571
M22 32 A2 Q4 VSS N L=1.2e-06 W=1.2e-05 AD=2.34e-11 AS=4.44e-11 PD=1.59e-05
+ PS=3.14e-05 NRD=0.1625 NRS=0.1625
M23 33 A1 32 VSS N L=1.2e-06 W=1.2e-05 AD=1.32e-11 AS=2.34e-11 PD=1.42e-05
+ PS=1.59e-05 NRD=0.0916667 NRS=0.1625
M24 VSS EN 33 VSS N L=1.2e-06 W=1.2e-05 AD=4.68e-11 AS=1.32e-11 PD=3.18e-05
+ PS=1.42e-05 NRD=0.1625 NRS=0.0916667
M25 34 EN VSS VSS N L=1.2e-06 W=1.2e-05 AD=1.2e-11 AS=4.68e-11 PD=1.4e-05
+ PS=3.18e-05 NRD=0.0833333 NRS=0.1625
M26 35 A1 34 VSS N L=1.2e-06 W=1.2e-05 AD=1.29e-11 AS=1.2e-11 PD=1.415e-05
+ PS=1.4e-05 NRD=0.0895833 NRS=0.0833333
M27 Q2 6 35 VSS N L=1.2e-06 W=1.2e-05 AD=4.8e-11 AS=1.29e-11 PD=3.2e-05
+ PS=1.415e-05 NRD=0.1625 NRS=0.0895833

.ends
*
* Design:   DELBUF
* Created:  "Fri Apr 10 20:35:11 2026"
* Vendor:   "Siemens"
* Program:  "Calibre xRC"
* Version:  "v2025.3_28.17"

*
.subckt DELBUF IN1 OUT1 VDD VSS
*
*
*

M0 VDD IN1 1 VDD P L=1.5e-06 W=4e-06 AD=5.75e-11 AS=1.48e-11 PD=3.84e-05
+ PS=1.54e-05 NRD=0.4375 NRS=0.4875
M1 OUT1 1 VDD VDD P L=1.5e-06 W=1.5e-05 AD=5.55e-11 AS=5.75e-11 PD=3.74e-05
+ PS=3.84e-05 NRD=0.13 NRS=0.13
M2 VSS IN1 1 VSS N L=1.2e-06 W=2.5e-06 AD=3.8435e-11 AS=1.42e-11 PD=2.85e-05
+ PS=1.54e-05 NRD=0.3 NRS=0.6
M3 OUT1 1 VSS VSS N L=1.2e-06 W=1.005e-05 AD=3.76875e-11 AS=3.8435e-11
+ PD=2.76e-05 PS=2.85e-05 NRD=0.199005 NRS=0.19403

.ends
*
* Design:   DFCL11
* Created:  "Thu Apr 16 12:33:14 2026"
* Vendor:   "Siemens"
* Program:  "Calibre xRC"
* Version:  "v2025.3_28.17"

*
.subckt DFCL11 C D CLRB QB Q VSS VDD
*
*
*

M0 VDD C 11 VDD P L=1.5e-06 W=1.59e-05 AD=1.0619e-10 AS=4.307e-11 PD=6.04e-05
+ PS=3.12e-05 NRD=0.137736 NRS=0.125786
M1 2 11 VDD VDD P L=1.5e-06 W=1.605e-05 AD=4.0145e-11 AS=1.0619e-10 PD=2.91e-05
+ PS=6.04e-05 NRD=0.128505 NRS=0.121495
M2 4 2 D VDD P L=1.5e-06 W=8e-06 AD=3.12e-11 AS=2.804e-11 PD=2.38e-05
+ PS=2.34e-05 NRD=0.24375 NRS=0.24375
M3 5 11 4 VDD P L=1.5e-06 W=8e-06 AD=3.2985e-11 AS=3.12e-11 PD=2.52e-05
+ PS=2.38e-05 NRD=0.24375 NRS=0.24375
M4 VDD 6 5 VDD P L=1.5e-06 W=8e-06 AD=2.96e-11 AS=3.2985e-11 PD=2.34e-05
+ PS=2.52e-05 NRD=0.24375 NRS=0.24375
M5 VDD 4 6 VDD P L=1.5e-06 W=1.2e-05 AD=4.68e-11 AS=4.44e-11 PD=3.18e-05
+ PS=3.14e-05 NRD=0.1625 NRS=0.1625
M6 6 CLRB VDD VDD P L=1.5e-06 W=1.2e-05 AD=4.48e-11 AS=4.68e-11 PD=3.18e-05
+ PS=3.18e-05 NRD=0.1625 NRS=0.1625
M7 12 11 6 VDD P L=1.5e-06 W=8e-06 AD=3.12e-11 AS=4.48e-11 PD=2.38e-05
+ PS=3.18e-05 NRD=0.24375 NRS=0.24375
M8 8 2 12 VDD P L=1.5e-06 W=8e-06 AD=3.12e-11 AS=3.12e-11 PD=2.38e-05
+ PS=2.38e-05 NRD=0.24375 NRS=0.24375
M9 VDD CLRB 8 VDD P L=1.5e-06 W=8e-06 AD=3.12e-11 AS=3.12e-11 PD=2.38e-05
+ PS=2.38e-05 NRD=0.24375 NRS=0.24375
M10 8 13 VDD VDD P L=1.5e-06 W=8e-06 AD=2.9005e-11 AS=3.12e-11 PD=2.34e-05
+ PS=2.38e-05 NRD=0.24375 NRS=0.24375
M11 VDD 12 13 VDD P L=1.5e-06 W=1.55e-05 AD=7.659e-11 AS=3.76587e-11
+ PD=4.88e-05 PS=2.74435e-05 NRD=0.125806 NRS=0.127419
M12 VDD 13 QB VDD P L=1.5e-06 W=2e-05 AD=7.8e-11 AS=7.4e-11 PD=4.78e-05
+ PS=4.74e-05 NRD=0.0975 NRS=0.0975
M13 Q QB VDD VDD P L=1.5e-06 W=2e-05 AD=7.4e-11 AS=7.8e-11 PD=4.74e-05
+ PS=4.78e-05 NRD=0.0975 NRS=0.0975
M14 11 C VSS VSS N L=1.25e-06 W=9.95e-06 AD=2.21225e-11 AS=5.4165e-11
+ PD=1.97e-05 PS=3.76e-05 NRD=0.243719 NRS=0.19598
M15 2 11 VSS VSS N L=1.2e-06 W=7.6e-06 AD=2.812e-11 AS=5.4165e-11 PD=2.26e-05
+ PS=3.76e-05 NRD=0.256579 NRS=0.256579
M16 4 11 D VSS N L=1.2e-06 W=6.5e-06 AD=2.535e-11 AS=2.405e-11 PD=2.08e-05
+ PS=2.04e-05 NRD=0.3 NRS=0.3
M17 5 2 4 VSS N L=1.2e-06 W=6.5e-06 AD=2.535e-11 AS=2.535e-11 PD=2.08e-05
+ PS=2.08e-05 NRD=0.3 NRS=0.3
M18 VSS 6 5 VSS N L=1.2e-06 W=6.5e-06 AD=3.015e-11 AS=2.535e-11 PD=2.38e-05
+ PS=2.08e-05 NRD=0.3 NRS=0.3
M19 34 4 VSS VSS N L=1.2e-06 W=8e-06 AD=8e-12 AS=3.015e-11 PD=1e-05 PS=2.38e-05
+ NRD=0.125 NRS=0.24375
M20 6 CLRB 34 VSS N L=1.2e-06 W=8e-06 AD=5.97e-11 AS=8e-12 PD=3.22e-05 PS=1e-05
+ NRD=0.43125 NRS=0.125
M21 12 2 6 VSS N L=1.2e-06 W=6.5e-06 AD=2.535e-11 AS=5.97e-11 PD=2.08e-05
+ PS=3.22e-05 NRD=0.3 NRS=0.484615
M22 8 11 12 VSS N L=1.2e-06 W=6.5e-06 AD=2.72275e-11 AS=2.535e-11 PD=2.18e-05
+ PS=2.08e-05 NRD=0.3 NRS=0.3
M23 35 CLRB 8 VSS N L=1.2e-06 W=6.95e-06 AD=6.95e-12 AS=2.72275e-11 PD=8.95e-06
+ PS=2.18e-05 NRD=0.143885 NRS=0.28777
M24 VSS 13 35 VSS N L=1.2e-06 W=6.95e-06 AD=3.78775e-11 AS=6.95e-12 PD=2.48e-05
+ PS=8.95e-06 NRD=0.503597 NRS=0.143885
M25 13 12 VSS VSS N L=1.2e-06 W=6.95e-06 AD=2.5715e-11 AS=3.78775e-11
+ PD=2.13e-05 PS=2.48e-05 NRD=0.280576 NRS=0.280576
M26 VSS 13 QB VSS N L=1.2e-06 W=9e-06 AD=3.51e-11 AS=3.33e-11 PD=2.58e-05
+ PS=2.54e-05 NRD=0.216667 NRS=0.216667
M27 Q QB VSS VSS N L=1.2e-06 W=9e-06 AD=3.6e-11 AS=3.51e-11 PD=2.6e-05
+ PS=2.58e-05 NRD=0.25 NRS=0.216667

.ends
*
* Design:   DFFL11
* Created:  "Fri Apr 10 20:37:54 2026"
* Vendor:   "Siemens"
* Program:  "Calibre xRC"
* Version:  "v2025.3_28.17"

*
.subckt DFFL11 C D QB Q VSS VDD
*
*
*

M0 VDD C 10 VDD P L=1.5e-06 W=1.6e-05 AD=6.24e-11 AS=5.92e-11 PD=3.98e-05
+ PS=3.94e-05 NRD=0.121875 NRS=0.121875
M1 2 10 VDD VDD P L=1.5e-06 W=1.6e-05 AD=5.92e-11 AS=6.24e-11 PD=3.94e-05
+ PS=3.98e-05 NRD=0.121875 NRS=0.121875
M2 4 2 D VDD P L=1.5e-06 W=8e-06 AD=3.12e-11 AS=2.96e-11 PD=2.38e-05
+ PS=2.34e-05 NRD=0.24375 NRS=0.24375
M3 5 10 4 VDD P L=1.5e-06 W=8e-06 AD=4.065e-11 AS=3.12e-11 PD=3e-05 PS=2.38e-05
+ NRD=0.24375 NRS=0.24375
M4 VDD 6 5 VDD P L=1.5e-06 W=1.33e-05 AD=8.58e-11 AS=4.065e-11 PD=5.32e-05
+ PS=3e-05 NRD=0.169173 NRS=0.177087
M5 6 4 VDD VDD P L=1.5e-06 W=1.4e-05 AD=4.1e-11 AS=8.58e-11 PD=3e-05
+ PS=5.32e-05 NRD=0.19881 NRS=0.148109
M6 11 10 6 VDD P L=1.5e-06 W=8e-06 AD=3.12e-11 AS=4.1e-11 PD=2.38e-05 PS=3e-05
+ NRD=0.24375 NRS=0.24375
M7 7 2 11 VDD P L=1.5e-06 W=8e-06 AD=5.67e-11 AS=3.12e-11 PD=3.88e-05
+ PS=2.38e-05 NRD=0.24375 NRS=0.24375
M8 VDD 12 7 VDD P L=1.5e-06 W=1.55e-05 AD=6.045e-11 AS=5.67e-11 PD=3.88e-05
+ PS=3.88e-05 NRD=0.125806 NRS=0.125806
M9 12 11 VDD VDD P L=1.5e-06 W=1.55e-05 AD=5.735e-11 AS=6.045e-11 PD=3.84e-05
+ PS=3.88e-05 NRD=0.125806 NRS=0.125806
M10 VDD 12 QB VDD P L=1.5e-06 W=2e-05 AD=7.8e-11 AS=7.4e-11 PD=4.78e-05
+ PS=4.74e-05 NRD=0.0975 NRS=0.0975
M11 Q QB VDD VDD P L=1.5e-06 W=2e-05 AD=7.4e-11 AS=7.8e-11 PD=4.74e-05
+ PS=4.78e-05 NRD=0.0975 NRS=0.0975
M12 VSS C 10 VSS N L=1.2e-06 W=1e-05 AD=3.9e-11 AS=3.7e-11 PD=2.78e-05
+ PS=2.74e-05 NRD=0.195 NRS=0.195
M13 2 10 VSS VSS N L=1.2e-06 W=1e-05 AD=3.7e-11 AS=3.9e-11 PD=2.74e-05
+ PS=2.78e-05 NRD=0.195 NRS=0.195
M14 4 10 D VSS N L=1.2e-06 W=6.5e-06 AD=2.73e-11 AS=2.6e-11 PD=2.14e-05
+ PS=2.1e-05 NRD=0.3 NRS=0.346154
M15 5 2 4 VSS N L=1.2e-06 W=6.5e-06 AD=2.6875e-11 AS=2.73e-11 PD=2.18e-05
+ PS=2.14e-05 NRD=0.3 NRS=0.346154
M16 VSS 6 5 VSS N L=1.2e-06 W=7e-06 AD=3.99e-11 AS=2.6875e-11 PD=2.54e-05
+ PS=2.18e-05 NRD=0.421429 NRS=0.278571
M17 6 4 VSS VSS N L=1.2e-06 W=7e-06 AD=2.6825e-11 AS=3.99e-11 PD=2.18e-05
+ PS=2.54e-05 NRD=0.278571 NRS=0.392857
M18 11 2 6 VSS N L=1.2e-06 W=6.5e-06 AD=2.665e-11 AS=2.6825e-11 PD=2.12e-05
+ PS=2.18e-05 NRD=0.330769 NRS=0.3
M19 7 10 11 VSS N L=1.2e-06 W=6.5e-06 AD=2.9525e-11 AS=2.665e-11 PD=2.26e-05
+ PS=2.12e-05 NRD=0.361538 NRS=0.3
M20 VSS 12 7 VSS N L=1.2e-06 W=7e-06 AD=2.73e-11 AS=2.9525e-11 PD=2.18e-05
+ PS=2.26e-05 NRD=0.278571 NRS=0.278571
M21 12 11 VSS VSS N L=1.2e-06 W=7e-06 AD=3.01e-11 AS=2.73e-11 PD=2.26e-05
+ PS=2.18e-05 NRD=0.364286 NRS=0.278571
M22 VSS 12 QB VSS N L=1.2e-06 W=1e-05 AD=4.2e-11 AS=4e-11 PD=2.84e-05
+ PS=2.8e-05 NRD=0.195 NRS=0.225
M23 Q QB VSS VSS N L=1.2e-06 W=1e-05 AD=3.7e-11 AS=4.2e-11 PD=2.74e-05
+ PS=2.84e-05 NRD=0.195 NRS=0.225

.ends
*

* Design:   DFPC11
* Created:  "Thu Apr 16 12:37:05 2026"
* Vendor:   "Siemens"
* Program:  "Calibre xRC"
* Version:  "v2025.3_28.17"

*

.subckt DFPC11 C D PRB CLRB  Q QB VSS VDD
*
*
*

M0 VDD C 12 VDD P L=1.5e-06 W=1.55e-05 AD=1.02505e-10 AS=3.811e-11 PD=6.01e-05
+ PS=2.8e-05 NRD=0.125806 NRS=0.127419
M1 2 12 VDD VDD P L=1.5e-06 W=1.55e-05 AD=3.811e-11 AS=1.02505e-10 PD=2.8e-05
+ PS=6.01e-05 NRD=0.126613 NRS=0.130846
M2 4 2 D VDD P L=1.5e-06 W=1e-05 AD=3.9e-11 AS=3.7e-11 PD=2.78e-05 PS=2.74e-05
+ NRD=0.195 NRS=0.195
M3 5 12 4 VDD P L=1.5e-06 W=1e-05 AD=6.2015e-11 AS=3.9e-11 PD=3.68e-05
+ PS=2.78e-05 NRD=0.3725 NRS=0.195
M4 VDD PRB 5 VDD P L=1.5e-06 W=1.505e-05 AD=1.03335e-10 AS=6.2015e-11
+ PD=6.13e-05 PS=3.68e-05 NRD=0.368771 NRS=0.181556
M5 5 8 VDD VDD P L=1.5e-06 W=1.55e-05 AD=3.8385e-11 AS=1.03335e-10 PD=2.8e-05
+ PS=6.13e-05 NRD=0.188172 NRS=0.125806
M6 VDD 4 8 VDD P L=1.5e-06 W=1.49e-05 AD=8.726e-11 AS=3.589e-11 PD=4.94e-05
+ PS=2.68e-05 NRD=0.151007 NRS=0.130872
M7 8 CLRB VDD VDD P L=1.5e-06 W=1.5e-05 AD=6.2e-11 AS=8.726e-11 PD=3.86e-05
+ PS=4.94e-05 NRD=0.156667 NRS=0.13
M8 13 12 8 VDD P L=1.5e-06 W=1e-05 AD=3.9e-11 AS=6.2e-11 PD=2.78e-05
+ PS=3.86e-05 NRD=0.195 NRS=0.195
M9 9 2 13 VDD P L=1.5e-06 W=1e-05 AD=5.648e-11 AS=3.9e-11 PD=3.52e-05
+ PS=2.78e-05 NRD=0.245 NRS=0.195
M10 VDD CLRB 9 VDD P L=1.5e-06 W=1.32e-05 AD=5.28e-11 AS=5.648e-11 PD=3.44e-05
+ PS=3.52e-05 NRD=0.147727 NRS=0.147727
M11 9 14 VDD VDD P L=1.5e-06 W=1.32e-05 AD=4.884e-11 AS=5.28e-11 PD=3.38e-05
+ PS=3.44e-05 NRD=0.147727 NRS=0.155303
M12 VDD 13 14 VDD P L=1.5e-06 W=1.55e-05 AD=6.51e-11 AS=5.735e-11 PD=3.94e-05
+ PS=3.84e-05 NRD=0.145161 NRS=0.125806
M13 14 PRB VDD VDD P L=1.5e-06 W=1.55e-05 AD=5.615e-11 AS=6.51e-11 PD=3.84e-05
+ PS=3.94e-05 NRD=0.125806 NRS=0.125806
M14 VDD 14 QB VDD P L=1.5e-06 W=2.38e-05 AD=1.1022e-10 AS=6.882e-11 PD=6.58e-05
+ PS=4.46e-05 NRD=0.0819328 NRS=0.113025
M15 Q QB VDD VDD P L=1.5e-06 W=2.15e-05 AD=7.955e-11 AS=1.1022e-10 PD=5.04e-05
+ PS=6.58e-05 NRD=0.0906977 NRS=0.100465
M16 VSS C 12 VSS N L=1.2e-06 W=1e-05 AD=3.9e-11 AS=3.7e-11 PD=2.78e-05
+ PS=2.74e-05 NRD=0.195 NRS=0.195
M17 2 12 VSS VSS N L=1.2e-06 W=1e-05 AD=3.7e-11 AS=3.9e-11 PD=2.74e-05
+ PS=2.78e-05 NRD=0.195 NRS=0.195
M18 4 12 D VSS N L=1.2e-06 W=1e-05 AD=3.9e-11 AS=3.7e-11 PD=2.78e-05
+ PS=2.74e-05 NRD=0.195 NRS=0.195
M19 5 2 4 VSS N L=1.2e-06 W=1e-05 AD=4.8e-11 AS=3.9e-11 PD=2.96e-05 PS=2.78e-05
+ NRD=0.195 NRS=0.195
M20 38 PRB 5 VSS N L=1.2e-06 W=1e-05 AD=1.975e-11 AS=4.8e-11 PD=1.395e-05
+ PS=2.96e-05 NRD=0.1975 NRS=0.285
M21 VSS 8 38 VSS N L=1.2e-06 W=1e-05 AD=1.195e-10 AS=1.975e-11 PD=4.39e-05
+ PS=1.395e-05 NRD=0.195 NRS=0.1975
M22 39 4 VSS VSS N L=1.2e-06 W=1e-05 AD=1.95e-11 AS=1.195e-10 PD=1.39e-05
+ PS=4.39e-05 NRD=0.195 NRS=0.2
M23 8 CLRB 39 VSS N L=1.2e-06 W=1e-05 AD=7.2e-11 AS=1.95e-11 PD=3.44e-05
+ PS=1.39e-05 NRD=0.225 NRS=0.195
M24 13 2 8 VSS N L=1.2e-06 W=1e-05 AD=3.9e-11 AS=7.2e-11 PD=2.78e-05
+ PS=3.44e-05 NRD=0.195 NRS=0.495
M25 9 12 13 VSS N L=1.2e-06 W=1e-05 AD=3.9e-11 AS=3.9e-11 PD=2.78e-05
+ PS=2.78e-05 NRD=0.195 NRS=0.195
M26 40 CLRB 9 VSS N L=1.2e-06 W=1e-05 AD=3.15e-11 AS=3.9e-11 PD=1.63e-05
+ PS=2.78e-05 NRD=0.315 NRS=0.195
M27 VSS 14 40 VSS N L=1.2e-06 W=1e-05 AD=3.9e-11 AS=3.15e-11 PD=2.78e-05
+ PS=1.63e-05 NRD=0.195 NRS=0.315
M28 41 13 VSS VSS N L=1.2e-06 W=1e-05 AD=1e-11 AS=3.9e-11 PD=1.2e-05
+ PS=2.78e-05 NRD=0.1 NRS=0.195
M29 14 PRB 41 VSS N L=1.2e-06 W=1e-05 AD=3.8e-11 AS=1e-11 PD=2.76e-05
+ PS=1.2e-05 NRD=0.195 NRS=0.1
M30 QB 14 VSS VSS N L=1.2e-06 W=1.25e-05 AD=2.812e-11 AS=8.47575e-11
+ PD=2.26e-05 PS=5.17e-05 NRD=0.166667 NRS=0.164348
M31 Q QB VSS VSS N L=1.2e-06 W=1.07e-05 AD=2.5955e-11 AS=8.47575e-11
+ PD=2.19e-05 PS=5.17e-05 NRD=0.180685 NRS=0.200794

.ends
*
* Design:   DFPR11
* Created:  "Fri Apr 17 15:04:12 2026"
* Vendor:   "Siemens"
* Program:  "Calibre xRC"
* Version:  "v2025.3_28.17"

*
.subckt DFPR11 C D PRB QB Q VSS VDD
*
*
*

M0 VDD C 12 VDD P L=1.5e-06 W=1.5e-05 AD=6.25e-11 AS=5.55e-11 PD=3.84e-05
+ PS=3.74e-05 NRD=0.13 NRS=0.13
M1 11 12 VDD VDD P L=1.5e-06 W=1.4e-05 AD=5.46e-11 AS=6.25e-11 PD=3.58e-05
+ PS=3.84e-05 NRD=0.182143 NRS=0.144231
M2 3 11 D VDD P L=1.5e-06 W=8e-06 AD=3.12e-11 AS=2.96e-11 PD=2.38e-05
+ PS=2.34e-05 NRD=0.24375 NRS=0.24375
M3 4 12 3 VDD P L=1.5e-06 W=8e-06 AD=3.195e-11 AS=3.12e-11 PD=2.44e-05
+ PS=2.38e-05 NRD=0.24375 NRS=0.24375
M4 VDD PRB 4 VDD P L=1.5e-06 W=5e-06 AD=1.95e-11 AS=3.195e-11 PD=1.78e-05
+ PS=2.44e-05 NRD=0.39 NRS=0.45
M5 4 6 VDD VDD P L=1.5e-06 W=5e-06 AD=1.85e-11 AS=1.95e-11 PD=1.74e-05
+ PS=1.78e-05 NRD=0.39 NRS=0.39
M6 6 3 VDD VDD P L=1.5e-06 W=1.22e-05 AD=4.914e-11 AS=4.575e-11 PD=3.28e-05
+ PS=3.19e-05 NRD=0.159836 NRS=0.163934
M7 7 12 6 VDD P L=1.5e-06 W=8e-06 AD=3.12e-11 AS=4.914e-11 PD=2.38e-05
+ PS=3.28e-05 NRD=0.24375 NRS=0.260417
M8 8 11 7 VDD P L=1.5e-06 W=8e-06 AD=3.12e-11 AS=3.12e-11 PD=2.38e-05
+ PS=2.38e-05 NRD=0.24375 NRS=0.24375
M9 VDD 13 8 VDD P L=1.5e-06 W=8e-06 AD=5.177e-11 AS=3.12e-11 PD=3.59e-05
+ PS=2.38e-05 NRD=0.24375 NRS=0.24375
M10 13 7 VDD VDD P L=1.5e-06 W=1.405e-05 AD=5.4795e-11 AS=5.177e-11 PD=3.59e-05
+ PS=3.59e-05 NRD=0.13879 NRS=0.13879
M11 VDD PRB 13 VDD P L=1.5e-06 W=1.405e-05 AD=5.1985e-11 AS=5.4795e-11
+ PD=3.55e-05 PS=3.59e-05 NRD=0.13879 NRS=0.13879
M12 VDD 13 QB VDD P L=1.5e-06 W=2e-05 AD=9.61675e-11 AS=5.476e-11 PD=5.82e-05
+ PS=3.7e-05 NRD=0.0975 NRS=0.1055
M13 Q QB VDD VDD P L=1.5e-06 W=1.805e-05 AD=6.6785e-11 AS=9.61675e-11
+ PD=4.35e-05 PS=5.82e-05 NRD=0.108033 NRS=0.109193
M14 VSS C 12 VSS N L=1.2e-06 W=7.85e-06 AD=3.0615e-11 AS=2.9045e-11 PD=2.35e-05
+ PS=2.31e-05 NRD=0.248408 NRS=0.248408
M15 11 12 VSS VSS N L=1.2e-06 W=7.85e-06 AD=3.0615e-11 AS=3.0615e-11
+ PD=2.35e-05 PS=2.35e-05 NRD=0.248408 NRS=0.248408
M16 3 12 D VSS N L=1.2e-06 W=8e-06 AD=3.12e-11 AS=2.96e-11 PD=2.38e-05
+ PS=2.34e-05 NRD=0.24375 NRS=0.24375
M17 4 11 3 VSS N L=1.2e-06 W=8e-06 AD=3.26e-11 AS=3.12e-11 PD=2.44e-05
+ PS=2.38e-05 NRD=0.24375 NRS=0.24375
M18 34 PRB 4 VSS N L=1.2e-06 W=6e-06 AD=1.17e-11 AS=3.26e-11 PD=9.9e-06
+ PS=2.44e-05 NRD=0.325 NRS=0.375
M19 VSS 6 34 VSS N L=1.2e-06 W=6e-06 AD=2.34e-11 AS=1.17e-11 PD=1.98e-05
+ PS=9.9e-06 NRD=0.325 NRS=0.325
M20 6 3 VSS VSS N L=1.2e-06 W=6e-06 AD=3.26e-11 AS=2.34e-11 PD=2.44e-05
+ PS=1.98e-05 NRD=0.375 NRS=0.325
M21 7 11 6 VSS N L=1.2e-06 W=8e-06 AD=5.76e-11 AS=3.26e-11 PD=3.04e-05
+ PS=2.44e-05 NRD=0.24375 NRS=0.24375
M22 8 12 7 VSS N L=1.2e-06 W=8e-06 AD=3.21e-11 AS=5.76e-11 PD=2.44e-05
+ PS=3.04e-05 NRD=0.24375 NRS=0.65625
M23 VSS 13 8 VSS N L=1.2e-06 W=5e-06 AD=1.85e-11 AS=3.21e-11 PD=1.74e-05
+ PS=2.44e-05 NRD=0.39 NRS=0.45
M24 35 7 VSS VSS N L=1.2e-06 W=9.95e-06 AD=9.95e-12 AS=3.6815e-11 PD=1.195e-05
+ PS=2.73e-05 NRD=0.100503 NRS=0.19598
M25 13 PRB 35 VSS N L=1.2e-06 W=9.95e-06 AD=3.6815e-11 AS=9.95e-12 PD=2.73e-05
+ PS=1.195e-05 NRD=0.19598 NRS=0.100503
M26 VSS 13 QB VSS N L=1.2e-06 W=8e-06 AD=3.12e-11 AS=2.96e-11 PD=2.38e-05
+ PS=2.34e-05 NRD=0.24375 NRS=0.24375
M27 Q QB VSS VSS N L=1.2e-06 W=8e-06 AD=3.3225e-11 AS=3.12e-11 PD=2.47e-05
+ PS=2.38e-05 NRD=0.28125 NRS=0.24375

.ends
*
* Design:   INVR01
* Created:  "Fri Apr 10 20:47:00 2026"
* Vendor:   "Siemens"
* Program:  "Calibre xRC"
* Version:  "v2025.3_28.17"

*
.subckt INVR01 IN1 OUT1 VDD VSS
*
*
*

M0 OUT1 IN1 VDD VDD P L=1.5e-06 W=1.4e-05 AD=5.18e-11 AS=5.46e-11 PD=3.54e-05
+ PS=3.58e-05 NRD=0.139286 NRS=0.139286
M1 OUT1 IN1 VSS VSS N L=1.2e-06 W=7e-06 AD=2.73e-11 AS=2.625e-11 PD=2.18e-05
+ PS=2.15e-05 NRD=0.3 NRS=0.285714

.ends
*
* Design:   INVR02
* Created:  "Fri Apr 10 20:47:41 2026"
* Vendor:   "Siemens"
* Program:  "Calibre xRC"
* Version:  "v2025.3_28.17"

*
.subckt INVR02 IN1 OUT1 VSS VDD
*
*
*

M0 OUT1 IN1 VDD VDD P L=1.5e-06 W=2.8e-05 AD=4.2e-11 AS=1.48202e-10 PD=2.9e-05
+ PS=8.5e-05 NRD=0.085 NRS=0.0742857
M1 OUT1 IN1 VSS VSS N L=1.2e-06 W=1.3e-05 AD=3.07275e-11 AS=7.1605e-11
+ PD=2.36e-05 PS=4.42e-05 NRD=0.161538 NRS=0.173077

.ends
*
* Design:   INVR03
* Created:  "Thu Apr 16 12:37:54 2026"
* Vendor:   "Siemens"
* Program:  "Calibre xRC"
* Version:  "v2025.3_28.17"

*
.subckt INVR03 IN1 OUT1 VSS VDD
*
*
*

M0 OUT1 IN1 VDD VDD P L=1.5e-06 W=3.9e-05 AD=6.4e-11 AS=1.85625e-10 PD=4e-05
+ PS=0.0001065 NRD=0.118803 NRS=0.0509615
M1 OUT1 IN1 VSS VSS N L=1.2e-06 W=1.7e-05 AD=2.12e-11 AS=1.1464e-10 PD=1.86e-05
+ PS=6.33e-05 NRD=0.131373 NRS=0.133333

.ends
*
* Design:   INVR04
* Created:  "Thu Apr 16 12:38:36 2026"
* Vendor:   "Siemens"
* Program:  "Calibre xRC"
* Version:  "v2025.3_28.17"

*
.subckt INVR04 IN1 OUT1 VSS VDD
*
*
*

M0 OUT1 IN1 VDD VDD P L=1.5e-06 W=2.5e-05 AD=9.45025e-11 AS=1.4341e-10
+ PD=4.7e-05 PS=8.17e-05 NRD=0.118 NRS=0.0784
M1 OUT1 IN1 VDD VDD P L=1.5e-06 W=2.5e-05 AD=9.45025e-11 AS=1.4341e-10
+ PD=4.7e-05 PS=8.17e-05 NRD=0.1276 NRS=0.08
M2 OUT1 IN1 VSS VSS N L=1.2e-06 W=2.2e-05 AD=4.08e-11 AS=1.2219e-10 PD=2.56e-05
+ PS=7.17e-05 NRD=0.127727 NRS=0.0939394

.ends
*
* Design:   INVR05
* Created:  "Fri Apr 10 20:48:50 2026"
* Vendor:   "Siemens"
* Program:  "Calibre xRC"
* Version:  "v2025.3_28.17"

*
.subckt INVR05 IN1 OUT1 VDD VSS
*
*
*

M0 OUT1 IN1 VDD VDD P L=1.5e-06 W=4.21e-05 AD=7.02e-11 AS=2.83365e-10
+ PD=4.31e-05 PS=0.0001294 NRD=-0.209422 NRS=0.125864
M1 OUT1 IN1 VDD VDD P L=1.5e-06 W=1.99e-05 AD=5.49375e-11 AS=2.83365e-10
+ PD=3.68e-05 PS=0.0001294 NRD=0.394472 NRS=0.285316
M2 OUT1 IN1 VSS VSS N L=1.2e-06 W=2.8e-05 AD=8.16e-11 AS=1.4322e-10 PD=3.76e-05
+ PS=8.34e-05 NRD=0.0920918 NRS=0.0734694

.ends
*
* Design:   INVR06
* Created:  "Thu Apr 16 12:41:45 2026"
* Vendor:   "Siemens"
* Program:  "Calibre xRC"
* Version:  "v2025.3_28.17"

*
.subckt INVR06 IN1 OUT1 VSS VDD
*
*
*

M0 OUT1 IN1 VDD VDD P L=1.5e-06 W=3.65e-05 AD=5.9e-11 AS=2.8841e-10 PD=3.75e-05
+ PS=0.0001579 NRD=-0.0381071 NRS=0.105628
M1 OUT1 IN1 VDD VDD P L=1.5e-06 W=3.65e-05 AD=5.9e-11 AS=2.8841e-10 PD=3.75e-05
+ PS=0.0001579 NRD=-0.0450685 NRS=0.0986672
M2 OUT1 IN1 VSS VSS N L=1.2e-06 W=3.3e-05 AD=8.6e-11 AS=1.6013e-10 PD=5.38e-05
+ PS=9.33e-05 NRD=0.123485 NRS=0.0608413

.ends
*
* Design:   LTCH11
* Created:  "Fri Apr 10 20:49:33 2026"
* Vendor:   "Siemens"
* Program:  "Calibre xRC"
* Version:  "v2025.3_28.17"

*
.subckt LTCH11 C D Q QB VSS VDD
*
*
*

M0 VDD C 8 VDD P L=1.5e-06 W=1.2e-05 AD=4.94e-11 AS=4.44e-11 PD=3.24e-05
+ PS=3.14e-05 NRD=0.1625 NRS=0.1625
M1 2 8 VDD VDD P L=1.5e-06 W=1e-05 AD=3.8e-11 AS=4.94e-11 PD=2.76e-05
+ PS=3.24e-05 NRD=0.205 NRS=0.216176
M2 4 8 D VDD P L=1.5e-06 W=1e-05 AD=5e-11 AS=3.7e-11 PD=3e-05 PS=2.74e-05
+ NRD=0.295 NRS=0.195
M3 5 2 4 VDD P L=1.5e-06 W=1e-05 AD=6.3015e-11 AS=5e-11 PD=3.52e-05 PS=3e-05
+ NRD=0.2725 NRS=0.205
M4 VDD 9 5 VDD P L=1.5e-06 W=8e-06 AD=6e-11 AS=6.3015e-11 PD=3.7e-05
+ PS=3.52e-05 NRD=0.297917 NRS=0.334375
M5 9 4 VDD VDD P L=1.5e-06 W=1.4e-05 AD=5.25e-11 AS=6e-11 PD=3.55e-05
+ PS=3.7e-05 NRD=0.139286 NRS=0.139286
M6 VDD 9 Q VDD P L=1.5e-06 W=1.63e-05 AD=6.357e-11 AS=6.031e-11 PD=4.04e-05
+ PS=4e-05 NRD=0.119632 NRS=0.119632
M7 QB Q VDD VDD P L=1.5e-06 W=1.63e-05 AD=6.031e-11 AS=6.357e-11 PD=4e-05
+ PS=4.04e-05 NRD=0.119632 NRS=0.119632
M8 VSS C 8 VSS N L=1.2e-06 W=6e-06 AD=2.34e-11 AS=2.22e-11 PD=1.98e-05
+ PS=1.94e-05 NRD=0.325 NRS=0.325
M9 2 8 VSS VSS N L=1.2e-06 W=6e-06 AD=2.22e-11 AS=2.34e-11 PD=1.94e-05
+ PS=1.98e-05 NRD=0.325 NRS=0.325
M10 4 2 D VSS N L=1.2e-06 W=6e-06 AD=2.46e-11 AS=2.22e-11 PD=2.02e-05
+ PS=1.94e-05 NRD=0.325 NRS=0.325
M11 5 8 4 VSS N L=1.2e-06 W=6e-06 AD=4.32e-11 AS=2.46e-11 PD=2.64e-05
+ PS=2.02e-05 NRD=0.325 NRS=0.358333
M12 VSS 9 5 VSS N L=1.2e-06 W=6e-06 AD=3.38e-11 AS=4.32e-11 PD=2.47e-05
+ PS=2.64e-05 NRD=0.308333 NRS=0.875
M13 9 4 VSS VSS N L=1.2e-06 W=8e-06 AD=2.96e-11 AS=3.38e-11 PD=2.34e-05
+ PS=2.47e-05 NRD=0.24375 NRS=0.28125
M14 VSS 9 Q VSS N L=1.2e-06 W=8.15e-06 AD=3.1785e-11 AS=3.0155e-11 PD=2.41e-05
+ PS=2.37e-05 NRD=0.239264 NRS=0.239264
M15 QB Q VSS VSS N L=1.2e-06 W=8.15e-06 AD=3.0155e-11 AS=3.1785e-11 PD=2.37e-05
+ PS=2.41e-05 NRD=0.239264 NRS=0.239264

.ends
*
* Design:   LTCL11
* Created:  "Thu Apr 16 17:01:00 2026"
* Vendor:   "Siemens"
* Program:  "Calibre xRC"
* Version:  "v2025.3_28.17"

*
.subckt LTCL11 C D CLRB Q QB VDD VSS
*
*
*

M0 VDD C 9 VDD P L=1.5e-06 W=1.1e-05 AD=4.545e-11 AS=4.07e-11 PD=3.04e-05
+ PS=2.94e-05 NRD=0.177273 NRS=0.177273
M1 2 9 VDD VDD P L=1.5e-06 W=9.5e-06 AD=3.515e-11 AS=4.545e-11 PD=2.64e-05
+ PS=3.04e-05 NRD=0.205263 NRS=0.236842
M2 4 9 D VDD P L=1.5e-06 W=1e-05 AD=3.9e-11 AS=3.7e-11 PD=2.78e-05 PS=2.74e-05
+ NRD=0.195 NRS=0.195
M3 5 2 4 VDD P L=1.5e-06 W=1e-05 AD=4.2e-11 AS=3.9e-11 PD=2.84e-05 PS=2.78e-05
+ NRD=0.195 NRS=0.195
M4 VDD 10 5 VDD P L=1.5e-06 W=1e-05 AD=5.4e-11 AS=4.2e-11 PD=3.08e-05
+ PS=2.84e-05 NRD=0.32 NRS=0.225
M5 10 4 VDD VDD P L=1.5e-06 W=1e-05 AD=3.9e-11 AS=5.4e-11 PD=2.78e-05
+ PS=3.08e-05 NRD=0.195 NRS=0.22
M6 VDD CLRB 10 VDD P L=1.5e-06 W=1e-05 AD=3.7e-11 AS=3.9e-11 PD=2.74e-05
+ PS=2.78e-05 NRD=0.195 NRS=0.195
M7 VDD 10 Q VDD P L=1.5e-06 W=1.9e-05 AD=1.23695e-10 AS=5.106e-11 PD=6.67e-05
+ PS=3.5e-05 NRD=0.102632 NRS=0.102632
M8 QB Q VDD VDD P L=1.5e-06 W=1.7e-05 AD=4.366e-11 AS=1.23695e-10 PD=3.1e-05
+ PS=6.67e-05 NRD=0.119118 NRS=0.160381
M9 VSS C 9 VSS N L=1.2e-06 W=5e-06 AD=1.95e-11 AS=1.85e-11 PD=1.78e-05
+ PS=1.74e-05 NRD=0.39 NRS=0.39
M10 2 9 VSS VSS N L=1.2e-06 W=5e-06 AD=1.85e-11 AS=1.95e-11 PD=1.74e-05
+ PS=1.78e-05 NRD=0.39 NRS=0.39
M11 4 2 D VSS N L=1.2e-06 W=5e-06 AD=2.6e-11 AS=2.805e-11 PD=2.04e-05
+ PS=2.26e-05 NRD=0.39 NRS=0.490909
M12 5 9 4 VSS N L=1.2e-06 W=5e-06 AD=2.1e-11 AS=2.6e-11 PD=1.84e-05 PS=2.04e-05
+ NRD=0.39 NRS=0.65
M13 VSS 10 5 VSS N L=1.2e-06 W=5e-06 AD=3.515e-11 AS=2.1e-11 PD=2.41e-05
+ PS=1.84e-05 NRD=0.59 NRS=0.45
M14 24 4 VSS VSS N L=1.2e-06 W=6e-06 AD=6e-12 AS=3.515e-11 PD=8e-06 PS=2.41e-05
+ NRD=0.166667 NRS=0.516667
M15 10 CLRB 24 VSS N L=1.2e-06 W=6e-06 AD=2.22e-11 AS=6e-12 PD=1.94e-05
+ PS=8e-06 NRD=0.325 NRS=0.166667
M16 Q 10 VSS VSS N L=1.2e-06 W=9.1e-06 AD=1.554e-11 AS=7.42e-11 PD=1.58e-05
+ PS=4.56e-05 NRD=0.214286 NRS=0.259554
M17 QB Q VSS VSS N L=1.2e-06 W=8.6e-06 AD=1.369e-11 AS=7.42e-11 PD=1.48e-05
+ PS=4.56e-05 NRD=0.226744 NRS=0.334079

.ends
*
* Design:   LTPC11
* Created:  "Fri Apr 10 20:54:46 2026"
* Vendor:   "Siemens"
* Program:  "Calibre xRC"
* Version:  "v2025.3_28.17"

*
.subckt LTPC11 C D PRB CLRB QB Q VDD VSS
*
*
*

M0 VDD C 11 VDD P L=1.5e-06 W=1.2e-05 AD=4.94e-11 AS=4.44e-11 PD=3.24e-05
+ PS=3.14e-05 NRD=0.1625 NRS=0.1625
M1 2 11 VDD VDD P L=1.5e-06 W=1e-05 AD=3.85e-11 AS=4.94e-11 PD=2.77e-05
+ PS=3.24e-05 NRD=0.21 NRS=0.225
M2 4 11 D VDD P L=1.5e-06 W=1e-05 AD=5.45e-11 AS=3.7e-11 PD=3.09e-05
+ PS=2.74e-05 NRD=0.34 NRS=0.195
M3 5 2 4 VDD P L=1.5e-06 W=1e-05 AD=9.941e-11 AS=5.45e-11 PD=4.98e-05
+ PS=3.09e-05 NRD=0.185 NRS=0.205
M4 VDD PRB 5 VDD P L=1.5e-06 W=1.8e-05 AD=8.1e-11 AS=9.941e-11 PD=4.5e-05
+ PS=4.98e-05 NRD=0.141667 NRS=0.108333
M5 5 7 VDD VDD P L=1.5e-06 W=1.8e-05 AD=6.75e-11 AS=8.1e-11 PD=4.35e-05
+ PS=4.5e-05 NRD=0.108333 NRS=0.108333
M6 7 4 VDD VDD P L=1.5e-06 W=1e-05 AD=3.9e-11 AS=3.7e-11 PD=2.78e-05
+ PS=2.74e-05 NRD=0.195 NRS=0.195
M7 VDD CLRB 7 VDD P L=1.5e-06 W=1e-05 AD=6.42e-11 AS=3.9e-11 PD=4.04e-05
+ PS=2.78e-05 NRD=0.195 NRS=0.195
M8 QB 5 VDD VDD P L=1.5e-06 W=1.6e-05 AD=5.92e-11 AS=6.42e-11 PD=3.94e-05
+ PS=4.04e-05 NRD=0.121875 NRS=0.133125
M9 Q QB VDD VDD P L=1.5e-06 W=1.5e-05 AD=5.55e-11 AS=5.55e-11 PD=3.74e-05
+ PS=3.74e-05 NRD=0.13 NRS=0.13
M10 VSS C 11 VSS N L=1.2e-06 W=6e-06 AD=2.34e-11 AS=2.22e-11 PD=1.98e-05
+ PS=1.94e-05 NRD=0.325 NRS=0.325
M11 2 11 VSS VSS N L=1.2e-06 W=6e-06 AD=2.28e-11 AS=2.34e-11 PD=1.96e-05
+ PS=1.98e-05 NRD=0.341667 NRS=0.325
M12 4 2 D VSS N L=1.2e-06 W=6e-06 AD=2.46e-11 AS=2.22e-11 PD=2.02e-05
+ PS=1.94e-05 NRD=0.325 NRS=0.325
M13 5 11 4 VSS N L=1.2e-06 W=6e-06 AD=7.813e-11 AS=2.46e-11 PD=3.83e-05
+ PS=2.02e-05 NRD=0.325 NRS=0.358333
M14 25 PRB 5 VSS N L=1.2e-06 W=1.195e-05 AD=2.33025e-11 AS=7.813e-11
+ PD=1.585e-05 PS=3.83e-05 NRD=0.16318 NRS=0.439331
M15 VSS 7 25 VSS N L=1.2e-06 W=1.195e-05 AD=4.4215e-11 AS=2.33025e-11
+ PD=3.13e-05 PS=1.585e-05 NRD=0.16318 NRS=0.16318
M16 26 4 7 VSS N L=1.2e-06 W=1e-05 AD=2.15e-11 AS=3.7e-11 PD=1.43e-05
+ PS=2.74e-05 NRD=0.215 NRS=0.195
M17 VSS CLRB 26 VSS N L=1.2e-06 W=1e-05 AD=3.8e-11 AS=2.15e-11 PD=2.78e-05
+ PS=1.43e-05 NRD=0.195 NRS=0.215
M18 QB 5 VSS VSS N L=1.2e-06 W=8e-06 AD=2.96e-11 AS=3.8e-11 PD=2.34e-05
+ PS=2.78e-05 NRD=0.24375 NRS=0.24375
M19 Q QB VSS VSS N L=1.2e-06 W=8e-06 AD=2.96e-11 AS=2.96e-11 PD=2.34e-05
+ PS=2.34e-05 NRD=0.24375 NRS=0.24375

.ends
*
* Design:   LTPR11
* Created:  "Fri Apr 10 20:56:28 2026"
* Vendor:   "Siemens"
* Program:  "Calibre xRC"
* Version:  "v2025.3_28.17"

*
.subckt LTPR11 C D PRB QB Q VDD VSS
*
*
*

M0 VDD 2 9 VDD P L=1.5e-06 W=1.25e-05 AD=4.875e-11 AS=4.625e-11 PD=3.28e-05
+ PS=3.24e-05 NRD=0.156 NRS=0.156
M1 2 C VDD VDD P L=1.5e-06 W=1.25e-05 AD=4.625e-11 AS=4.875e-11 PD=3.24e-05
+ PS=3.28e-05 NRD=0.156 NRS=0.156
M2 10 2 D VDD P L=1.5e-06 W=1.25e-05 AD=4.875e-11 AS=4.625e-11 PD=3.28e-05
+ PS=3.24e-05 NRD=0.156 NRS=0.156
M3 5 9 10 VDD P L=1.5e-06 W=1.25e-05 AD=4.875e-11 AS=4.875e-11 PD=3.28e-05
+ PS=3.28e-05 NRD=0.156 NRS=0.156
M4 VDD PRB 5 VDD P L=1.5e-06 W=1.25e-05 AD=5.125e-11 AS=4.875e-11 PD=3.32e-05
+ PS=3.28e-05 NRD=0.156 NRS=0.156
M5 5 6 VDD VDD P L=1.5e-06 W=1.25e-05 AD=4.625e-11 AS=5.125e-11 PD=3.24e-05
+ PS=3.32e-05 NRD=0.156 NRS=0.172
M6 6 10 VDD VDD P L=1.5e-06 W=1.005e-05 AD=3.7185e-11 AS=3.7185e-11 PD=2.75e-05
+ PS=2.75e-05 NRD=0.19403 NRS=0.19403
M7 VDD 5 QB VDD P L=1.5e-06 W=1.6e-05 AD=6.24e-11 AS=5.92e-11 PD=3.98e-05
+ PS=3.94e-05 NRD=0.121875 NRS=0.121875
M8 Q QB VDD VDD P L=1.5e-06 W=1.6e-05 AD=5.92e-11 AS=6.24e-11 PD=3.94e-05
+ PS=3.98e-05 NRD=0.121875 NRS=0.121875
M9 VSS 2 9 VSS N L=1.2e-06 W=6.5e-06 AD=2.535e-11 AS=2.405e-11 PD=2.08e-05
+ PS=2.04e-05 NRD=0.3 NRS=0.3
M10 2 C VSS VSS N L=1.2e-06 W=6.5e-06 AD=2.405e-11 AS=2.535e-11 PD=2.04e-05
+ PS=2.08e-05 NRD=0.3 NRS=0.3
M11 10 9 D VSS N L=1.2e-06 W=6.25e-06 AD=2.4375e-11 AS=2.3125e-11 PD=2.03e-05
+ PS=1.99e-05 NRD=0.312 NRS=0.312
M12 5 2 10 VSS N L=1.2e-06 W=6.25e-06 AD=4.3825e-11 AS=2.4375e-11 PD=3.04e-05
+ PS=2.03e-05 NRD=0.32 NRS=0.312
M13 23 PRB 5 VSS N L=1.2e-06 W=1.1e-05 AD=1.485e-11 AS=4.3825e-11 PD=1.37e-05
+ PS=3.04e-05 NRD=0.122727 NRS=0.177273
M14 VSS 6 23 VSS N L=1.2e-06 W=1.1e-05 AD=4.645e-11 AS=1.485e-11 PD=3.09e-05
+ PS=1.37e-05 NRD=0.2 NRS=0.122727
M15 6 10 VSS VSS N L=1.2e-06 W=6e-06 AD=2.28e-11 AS=4.645e-11 PD=1.96e-05
+ PS=3.09e-05 NRD=0.325 NRS=0.375
M16 VSS 5 QB VSS N L=1.2e-06 W=7e-06 AD=2.73e-11 AS=2.59e-11 PD=2.18e-05
+ PS=2.14e-05 NRD=0.278571 NRS=0.278571
M17 Q QB VSS VSS N L=1.2e-06 W=7e-06 AD=2.59e-11 AS=2.73e-11 PD=2.14e-05
+ PS=2.18e-05 NRD=0.278571 NRS=0.278571

.ends
*
* Design:   MX201B
* Created:  "Fri Apr 10 21:01:14 2026"
* Vendor:   "Siemens"
* Program:  "Calibre xRC"
* Version:  "v2025.3_28.17"

*
.subckt MX201B A0 D0 D1 OUTB VDD VSS
*
*
*

M0 2 A0 VDD VDD P L=1.5e-06 W=1.4e-05 AD=5.18e-11 AS=5.46e-11 PD=3.54e-05
+ PS=3.58e-05 NRD=0.139286 NRS=0.139286
M1 4 A0 D0 VDD P L=1.5e-06 W=1.05e-05 AD=7.755e-11 AS=3.885e-11 PD=3.68e-05
+ PS=2.84e-05 NRD=0.579365 NRS=0.185714
M2 D1 2 4 VDD P L=1.5e-06 W=1.05e-05 AD=3.885e-11 AS=7.755e-11 PD=2.84e-05
+ PS=3.68e-05 NRD=-0.0428571 NRS=0.307453
M3 OUTB 4 VDD VDD P L=1.5e-06 W=1.405e-05 AD=5.1985e-11 AS=5.1985e-11
+ PD=3.55e-05 PS=3.55e-05 NRD=0.13879 NRS=0.13879
M4 2 A0 VSS VSS N L=1.2e-06 W=7e-06 AD=2.73e-11 AS=2.625e-11 PD=2.18e-05
+ PS=2.15e-05 NRD=0.3 NRS=0.285714
M5 4 2 D0 VSS N L=1.2e-06 W=9e-06 AD=6.21e-11 AS=3.33e-11 PD=3.18e-05
+ PS=2.54e-05 NRD=0.994444 NRS=0.216667
M6 D1 A0 4 VSS N L=1.2e-06 W=9e-06 AD=3.33e-11 AS=6.21e-11 PD=2.54e-05
+ PS=3.18e-05 NRD=0.0833333 NRS=0.485294
M7 OUTB 4 VSS VSS N L=1.2e-06 W=7e-06 AD=2.59e-11 AS=2.625e-11 PD=2.14e-05
+ PS=2.15e-05 NRD=0.278571 NRS=0.278571

.ends
*

* Design:   MX2101
* Created:  "Fri Apr 10 21:01:52 2026"
* Vendor:   "Siemens"
* Program:  "Calibre xRC"
* Version:  "v2025.3_28.17"

*
.subckt MX2101 A0 D0 OUT1 D1 VDD VSS
*
*
*

M0 2 A0 VDD VDD P L=1.5e-06 W=1.4e-05 AD=5.18e-11 AS=5.46e-11 PD=3.54e-05
+ PS=3.58e-05 NRD=0.139286 NRS=0.139286
M1 OUT1 A0 D0 VDD P L=1.5e-06 W=1.4e-05 AD=7.54e-11 AS=5.005e-11 PD=4.03e-05
+ PS=3.68e-05 NRD=0.228571 NRS=0.139286
M2 D1 2 OUT1 VDD P L=1.5e-06 W=1.4e-05 AD=5.18e-11 AS=7.54e-11 PD=3.54e-05
+ PS=4.03e-05 NRD=0.139286 NRS=0.139286
M3 2 A0 VSS VSS N L=1.2e-06 W=7e-06 AD=2.73e-11 AS=2.625e-11 PD=2.18e-05
+ PS=2.15e-05 NRD=0.3 NRS=0.285714
M4 OUT1 2 D0 VSS N L=1.2e-06 W=9e-06 AD=6.21e-11 AS=3.33e-11 PD=3.18e-05
+ PS=2.54e-05 NRD=1 NRS=0.216667
M5 D1 A0 OUT1 VSS N L=1.2e-06 W=9e-06 AD=3.33e-11 AS=6.21e-11 PD=2.54e-05
+ PS=3.18e-05 NRD=0.0833333 NRS=0.5

.ends
*

*
* Design:   MX4122
* Created:  "Fri Apr 10 21:04:47 2026"
* Vendor:   "Siemens"
* Program:  "Calibre xRC"
* Version:  "v2025.3_28.17"

*
.subckt MX4122 A0 D0 D2 D1 D3 OUT1 A1 VSS VDD
*
*
*

M0 VDD A0 17 VDD P L=1.5e-06 W=1.6e-05 AD=6.24e-11 AS=5.92e-11 PD=3.98e-05
+ PS=3.94e-05 NRD=0.121875 NRS=0.121875
M1 2 17 VDD VDD P L=1.5e-06 W=1.6e-05 AD=5.92e-11 AS=6.24e-11 PD=3.94e-05
+ PS=3.98e-05 NRD=0.121875 NRS=0.121875
M2 4 D0 VDD VDD P L=1.5e-06 W=1.5e-05 AD=5.65e-11 AS=5.55e-11 PD=3.78e-05
+ PS=3.74e-05 NRD=0.13 NRS=0.13
M3 5 2 4 VDD P L=1.5e-06 W=1.1e-05 AD=4.29e-11 AS=5.65e-11 PD=2.98e-05
+ PS=3.78e-05 NRD=0.177273 NRS=0.177273
M4 6 17 5 VDD P L=1.5e-06 W=1.1e-05 AD=5.65e-11 AS=4.29e-11 PD=3.78e-05
+ PS=2.98e-05 NRD=0.177273 NRS=0.177273
M5 VDD D1 6 VDD P L=1.5e-06 W=1.5e-05 AD=5.55e-11 AS=5.65e-11 PD=3.74e-05
+ PS=3.78e-05 NRD=0.13 NRS=0.13
M6 9 D2 VDD VDD P L=1.5e-06 W=1.5e-05 AD=5.65e-11 AS=5.55e-11 PD=3.78e-05
+ PS=3.74e-05 NRD=0.13 NRS=0.13
M7 10 2 9 VDD P L=1.5e-06 W=1.1e-05 AD=4.29e-11 AS=5.65e-11 PD=2.98e-05
+ PS=3.78e-05 NRD=0.177273 NRS=0.177273
M8 11 17 10 VDD P L=1.5e-06 W=1.1e-05 AD=5.65e-11 AS=4.29e-11 PD=3.78e-05
+ PS=2.98e-05 NRD=0.177273 NRS=0.177273
M9 VDD D3 11 VDD P L=1.5e-06 W=1.5e-05 AD=5.55e-11 AS=5.65e-11 PD=3.74e-05
+ PS=3.78e-05 NRD=0.13 NRS=0.13
M10 13 20 10 VDD P L=1.5e-06 W=1.3e-05 AD=5.07e-11 AS=4.81e-11 PD=3.38e-05
+ PS=3.34e-05 NRD=0.15 NRS=0.15
M11 5 15 13 VDD P L=1.5e-06 W=1.3e-05 AD=4.81e-11 AS=5.07e-11 PD=3.34e-05
+ PS=3.38e-05 NRD=0.15 NRS=0.15
M12 OUT1 13 VDD VDD P L=1.5e-06 W=1.98e-05 AD=7.04e-11 AS=1.1534e-10
+ PD=3.66e-05 PS=6.82e-05 NRD=0.133838 NRS=0.100216
M13 15 20 VDD VDD P L=1.5e-06 W=1.8e-05 AD=4.736e-11 AS=1.1534e-10 PD=3.3e-05
+ PS=6.82e-05 NRD=0.109722 NRS=0.111031
M14 20 A1 VDD VDD P L=1.5e-06 W=1.8e-05 AD=4.736e-11 AS=8.584e-11 PD=3.3e-05
+ PS=5.38e-05 NRD=0.109444 NRS=0.110632
M15 VSS A0 17 VSS N L=1.2e-06 W=9e-06 AD=3.51e-11 AS=3.33e-11 PD=2.58e-05
+ PS=2.54e-05 NRD=0.216667 NRS=0.216667
M16 2 17 VSS VSS N L=1.2e-06 W=9e-06 AD=3.33e-11 AS=3.51e-11 PD=2.54e-05
+ PS=2.58e-05 NRD=0.216667 NRS=0.216667
M17 4 D0 VSS VSS N L=1.2e-06 W=7e-06 AD=4.035e-11 AS=2.59e-11 PD=2.84e-05
+ PS=2.14e-05 NRD=0.321429 NRS=0.278571
M18 5 17 4 VSS N L=1.2e-06 W=1e-05 AD=3.9e-11 AS=4.035e-11 PD=2.78e-05
+ PS=2.84e-05 NRD=0.195 NRS=0.195
M19 6 2 5 VSS N L=1.2e-06 W=1e-05 AD=3.915e-11 AS=3.9e-11 PD=2.84e-05
+ PS=2.78e-05 NRD=0.195 NRS=0.195
M20 VSS D1 6 VSS N L=1.2e-06 W=7e-06 AD=2.59e-11 AS=3.915e-11 PD=2.14e-05
+ PS=2.84e-05 NRD=0.278571 NRS=0.321429
M21 9 D2 VSS VSS N L=1.2e-06 W=7e-06 AD=4.05e-11 AS=2.59e-11 PD=2.84e-05
+ PS=2.14e-05 NRD=0.321429 NRS=0.278571
M22 10 17 9 VSS N L=1.2e-06 W=1e-05 AD=3.9e-11 AS=4.05e-11 PD=2.78e-05
+ PS=2.84e-05 NRD=0.195 NRS=0.195
M23 11 2 10 VSS N L=1.2e-06 W=1e-05 AD=4.12e-11 AS=3.9e-11 PD=2.86e-05
+ PS=2.78e-05 NRD=0.195 NRS=0.195
M24 VSS D3 11 VSS N L=1.2e-06 W=7e-06 AD=2.835e-11 AS=4.12e-11 PD=2.21e-05
+ PS=2.86e-05 NRD=0.328571 NRS=0.335714
M25 13 15 10 VSS N L=1.2e-06 W=1.1e-05 AD=4.29e-11 AS=4.07e-11 PD=2.98e-05
+ PS=2.94e-05 NRD=0.177273 NRS=0.177273
M26 5 20 13 VSS N L=1.2e-06 W=1.1e-05 AD=4.07e-11 AS=4.29e-11 PD=2.94e-05
+ PS=2.98e-05 NRD=0.177273 NRS=0.177273
M27 OUT1 13 VSS VSS N L=1.2e-06 W=9e-06 AD=3.51e-11 AS=3.33e-11 PD=2.58e-05
+ PS=2.54e-05 NRD=0.216667 NRS=0.216667
M28 VSS 13 OUT1 VSS N L=1.2e-06 W=9e-06 AD=3.51e-11 AS=3.51e-11 PD=2.58e-05
+ PS=2.58e-05 NRD=0.216667 NRS=0.216667
M29 15 20 VSS VSS N L=1.2e-06 W=9e-06 AD=3.33e-11 AS=3.51e-11 PD=2.54e-05
+ PS=2.58e-05 NRD=0.216667 NRS=0.216667
M30 20 A1 VSS VSS N L=1.2e-06 W=9e-06 AD=3.33e-11 AS=3.33e-11 PD=2.54e-05
+ PS=2.54e-05 NRD=0.216667 NRS=0.216667

.ends
*
* Design:   NND201
* Created:  "Fri Apr 10 21:05:35 2026"
* Vendor:   "Siemens"
* Program:  "Calibre xRC"
* Version:  "v2025.3_28.17"

*
.subckt NND201 IN1 IN2 OUT1 VSS VDD
*
*
*

M0 OUT1 IN1 VDD VDD P L=1.5e-06 W=2e-05 AD=7.8e-11 AS=7.4e-11 PD=4.78e-05
+ PS=4.74e-05 NRD=0.0975 NRS=0.0975
M1 VDD IN2 OUT1 VDD P L=1.5e-06 W=2e-05 AD=7.4e-11 AS=7.8e-11 PD=4.74e-05
+ PS=4.78e-05 NRD=0.0975 NRS=0.0975
M2 9 IN1 VSS VSS N L=1.2e-06 W=1.4e-05 AD=1.19e-11 AS=5.18e-11 PD=1.57e-05
+ PS=3.54e-05 NRD=0.0607143 NRS=0.139286
M3 OUT1 IN2 9 VSS N L=1.2e-06 W=1.4e-05 AD=5.78e-11 AS=1.19e-11 PD=3.68e-05
+ PS=1.57e-05 NRD=0.139286 NRS=0.0607143

.ends
*
* Design:   NND300
* Created:  "Fri Apr 10 21:06:14 2026"
* Vendor:   "Siemens"
* Program:  "Calibre xRC"
* Version:  "v2025.3_28.17"

*
.subckt NND300 IN3 IN2 IN1 OUT1 VSS VDD
*
*
*

M0 OUT1 IN3 VDD VDD P L=1.5e-06 W=1.55e-05 AD=6.045e-11 AS=5.735e-11
+ PD=3.88e-05 PS=3.84e-05 NRD=0.125806 NRS=0.125806
M1 VDD IN2 OUT1 VDD P L=1.5e-06 W=1.55e-05 AD=6.045e-11 AS=6.045e-11
+ PD=3.88e-05 PS=3.88e-05 NRD=0.125806 NRS=0.125806
M2 OUT1 IN1 VDD VDD P L=1.5e-06 W=1.55e-05 AD=5.735e-11 AS=6.045e-11
+ PD=3.84e-05 PS=3.88e-05 NRD=0.125806 NRS=0.125806
M3 11 IN3 VSS VSS N L=1.2e-06 W=1.55e-05 AD=1.705e-11 AS=5.735e-11 PD=1.77e-05
+ PS=3.84e-05 NRD=0.0709677 NRS=0.125806
M4 12 IN2 11 VSS N L=1.2e-06 W=1.55e-05 AD=1.6275e-11 AS=1.705e-11 PD=1.76e-05
+ PS=1.77e-05 NRD=0.0677419 NRS=0.0709677
M5 OUT1 IN1 12 VSS N L=1.2e-06 W=1.55e-05 AD=5.735e-11 AS=1.6275e-11
+ PD=3.84e-05 PS=1.76e-05 NRD=0.125806 NRS=0.0677419

.ends
*
* Design:   NND301
* Created:  "Fri Apr 17 15:00:24 2026"
* Vendor:   "Siemens"
* Program:  "Calibre xRC"
* Version:  "v2025.3_28.17"

*
.subckt NND301 IN3 IN2 IN1 OUT1 VSS VDD
*
*
*

M0 5 IN3 VDD VDD P L=1.5e-06 W=8e-06 AD=3.12e-11 AS=2.96e-11 PD=2.38e-05
+ PS=2.34e-05 NRD=0.24375 NRS=0.24375
M1 VDD IN2 5 VDD P L=1.5e-06 W=8e-06 AD=3.12e-11 AS=3.12e-11 PD=2.38e-05
+ PS=2.38e-05 NRD=0.24375 NRS=0.24375
M2 5 IN1 VDD VDD P L=1.5e-06 W=8e-06 AD=2.96e-11 AS=3.12e-11 PD=2.34e-05
+ PS=2.38e-05 NRD=0.24375 NRS=0.24375
M3 VDD 5 6 VDD P L=1.5e-06 W=1.6e-05 AD=6.24e-11 AS=5.92e-11 PD=3.98e-05
+ PS=3.94e-05 NRD=0.121875 NRS=0.121875
M4 OUT1 6 VDD VDD P L=1.5e-06 W=1.6e-05 AD=5.92e-11 AS=6.24e-11 PD=3.94e-05
+ PS=3.98e-05 NRD=0.121875 NRS=0.121875
M5 15 IN3 VSS VSS N L=1.2e-06 W=8e-06 AD=7.2e-12 AS=2.96e-11 PD=9.8e-06
+ PS=2.34e-05 NRD=0.1125 NRS=0.24375
M6 16 IN2 15 VSS N L=1.2e-06 W=8e-06 AD=1e-11 AS=7.2e-12 PD=1.05e-05 PS=9.8e-06
+ NRD=0.15625 NRS=0.1125
M7 5 IN1 16 VSS N L=1.2e-06 W=8e-06 AD=2.96e-11 AS=1e-11 PD=2.34e-05
+ PS=1.05e-05 NRD=0.24375 NRS=0.15625
M8 VSS 5 6 VSS N L=1.2e-06 W=7e-06 AD=2.94e-11 AS=2.8e-11 PD=2.24e-05
+ PS=2.2e-05 NRD=0.278571 NRS=0.321429
M9 OUT1 6 VSS VSS N L=1.2e-06 W=7e-06 AD=2.59e-11 AS=2.94e-11 PD=2.14e-05
+ PS=2.24e-05 NRD=0.278571 NRS=0.321429

.ends
*
* Design:   NND401
* Created:  "Thu Apr 16 12:59:43 2026"
* Vendor:   "Siemens"
* Program:  "Calibre xRC"
* Version:  "v2025.3_28.17"

*
.subckt NND401 IN4 IN3 IN2 IN1 OUT1 VSS VDD
*
*
*

M0 6 IN4 VDD VDD P L=1.5e-06 W=1e-05 AD=3.9e-11 AS=3.7e-11 PD=2.78e-05
+ PS=2.74e-05 NRD=0.195 NRS=0.195
M1 VDD IN3 6 VDD P L=1.5e-06 W=1e-05 AD=3.9e-11 AS=3.9e-11 PD=2.78e-05
+ PS=2.78e-05 NRD=0.195 NRS=0.195
M2 6 IN2 VDD VDD P L=1.5e-06 W=1e-05 AD=3.9e-11 AS=3.9e-11 PD=2.78e-05
+ PS=2.78e-05 NRD=0.195 NRS=0.195
M3 VDD IN1 6 VDD P L=1.5e-06 W=1e-05 AD=3.7e-11 AS=3.9e-11 PD=2.74e-05
+ PS=2.78e-05 NRD=0.195 NRS=0.195
M4 VDD 6 7 VDD P L=1.5e-06 W=1.55e-05 AD=6.045e-11 AS=5.735e-11 PD=3.88e-05
+ PS=3.84e-05 NRD=0.125806 NRS=0.125806
M5 OUT1 7 VDD VDD P L=1.5e-06 W=1.55e-05 AD=5.735e-11 AS=6.045e-11 PD=3.84e-05
+ PS=3.88e-05 NRD=0.125806 NRS=0.125806
M6 17 IN4 VSS VSS N L=1.2e-06 W=1e-05 AD=1.3e-11 AS=3.7e-11 PD=1.26e-05
+ PS=2.74e-05 NRD=0.13 NRS=0.195
M7 18 IN3 17 VSS N L=1.2e-06 W=1e-05 AD=1.05e-11 AS=1.3e-11 PD=1.21e-05
+ PS=1.26e-05 NRD=0.105 NRS=0.13
M8 19 IN2 18 VSS N L=1.2e-06 W=1e-05 AD=1.95e-11 AS=1.05e-11 PD=1.39e-05
+ PS=1.21e-05 NRD=0.195 NRS=0.105
M9 6 IN1 19 VSS N L=1.2e-06 W=1e-05 AD=3.7e-11 AS=1.95e-11 PD=2.74e-05
+ PS=1.39e-05 NRD=0.195 NRS=0.195
M10 VSS 6 7 VSS N L=1.2e-06 W=7e-06 AD=2.94e-11 AS=2.8e-11 PD=2.24e-05
+ PS=2.2e-05 NRD=0.278571 NRS=0.321429
M11 OUT1 7 VSS VSS N L=1.2e-06 W=7e-06 AD=2.59e-11 AS=2.94e-11 PD=2.14e-05
+ PS=2.24e-05 NRD=0.278571 NRS=0.321429

.ends
*
* Design:   NND501
* Created:  "Fri Apr 10 21:10:50 2026"
* Vendor:   "Siemens"
* Program:  "Calibre xRC"
* Version:  "v2025.3_28.17"

*
.subckt NND501 IN5 IN4 IN3 IN2 IN1 OUT1 VDD VSS
*
*
*

M0 7 IN5 VDD VDD P L=1.5e-06 W=1e-05 AD=3.9e-11 AS=3.7e-11 PD=2.78e-05
+ PS=2.74e-05 NRD=0.195 NRS=0.195
M1 VDD IN4 7 VDD P L=1.5e-06 W=1e-05 AD=3.9e-11 AS=3.9e-11 PD=2.78e-05
+ PS=2.78e-05 NRD=0.195 NRS=0.195
M2 7 IN3 VDD VDD P L=1.5e-06 W=1e-05 AD=3.9e-11 AS=3.9e-11 PD=2.78e-05
+ PS=2.78e-05 NRD=0.195 NRS=0.195
M3 VDD IN2 7 VDD P L=1.5e-06 W=1e-05 AD=3.9e-11 AS=3.9e-11 PD=2.78e-05
+ PS=2.78e-05 NRD=0.195 NRS=0.195
M4 7 IN1 VDD VDD P L=1.5e-06 W=1e-05 AD=3.7e-11 AS=3.9e-11 PD=2.74e-05
+ PS=2.78e-05 NRD=0.195 NRS=0.195
M5 VDD 7 8 VDD P L=1.5e-06 W=1.25e-05 AD=6.225e-11 AS=4.625e-11 PD=3.7e-05
+ PS=3.24e-05 NRD=0.18 NRS=0.156
M6 OUT1 8 VDD VDD P L=1.5e-06 W=1.4e-05 AD=5.18e-11 AS=6.225e-11 PD=3.54e-05
+ PS=3.7e-05 NRD=0.139286 NRS=0.160714
M7 19 IN5 VSS VSS N L=1.2e-06 W=1e-05 AD=1.3e-11 AS=3.7e-11 PD=1.26e-05
+ PS=2.74e-05 NRD=0.13 NRS=0.195
M8 20 IN4 19 VSS N L=1.2e-06 W=1e-05 AD=1.05e-11 AS=1.3e-11 PD=1.21e-05
+ PS=1.26e-05 NRD=0.105 NRS=0.13
M9 21 IN3 20 VSS N L=1.2e-06 W=1e-05 AD=2.25e-11 AS=1.05e-11 PD=1.45e-05
+ PS=1.21e-05 NRD=0.225 NRS=0.105
M10 22 IN2 21 VSS N L=1.2e-06 W=1e-05 AD=1.5e-11 AS=2.25e-11 PD=1.3e-05
+ PS=1.45e-05 NRD=0.15 NRS=0.225
M11 7 IN1 22 VSS N L=1.2e-06 W=1e-05 AD=3.7e-11 AS=1.5e-11 PD=2.74e-05
+ PS=1.3e-05 NRD=0.195 NRS=0.15
M12 VSS 7 8 VSS N L=1.2e-06 W=6.5e-06 AD=3.72e-11 AS=2.6e-11 PD=2.56e-05
+ PS=2.1e-05 NRD=0.392308 NRS=0.346154
M13 OUT1 8 VSS VSS N L=1.2e-06 W=8e-06 AD=2.96e-11 AS=3.72e-11 PD=2.34e-05
+ PS=2.56e-05 NRD=0.24375 NRS=0.28125

.ends
*
* Design:   NND601
* Created:  "Thu Apr 16 12:56:40 2026"
* Vendor:   "Siemens"
* Program:  "Calibre xRC"
* Version:  "v2025.3_28.17"

*
.subckt NND601 IN1 IN2 IN3 IN6 IN5 IN4 OUT1 VSS VDD
*
*
*

M0 VDD IN1 9 VDD P L=1.5e-06 W=1.46e-05 AD=5.694e-11 AS=5.548e-11 PD=3.7e-05
+ PS=3.68e-05 NRD=0.133562 NRS=0.133562
M1 9 IN2 VDD VDD P L=1.5e-06 W=1.46e-05 AD=5.694e-11 AS=5.694e-11 PD=3.7e-05
+ PS=3.7e-05 NRD=0.133562 NRS=0.133562
M2 VDD IN3 9 VDD P L=1.5e-06 W=1.46e-05 AD=5.694e-11 AS=5.694e-11 PD=3.7e-05
+ PS=3.7e-05 NRD=0.133562 NRS=0.133562
M3 8 IN6 VDD VDD P L=1.5e-06 W=1.46e-05 AD=5.694e-11 AS=5.694e-11 PD=3.7e-05
+ PS=3.7e-05 NRD=0.133562 NRS=0.133562
M4 VDD IN5 8 VDD P L=1.5e-06 W=1.46e-05 AD=5.694e-11 AS=5.694e-11 PD=3.7e-05
+ PS=3.7e-05 NRD=0.133562 NRS=0.133562
M5 8 IN4 VDD VDD P L=1.5e-06 W=1.46e-05 AD=5.402e-11 AS=5.694e-11 PD=3.66e-05
+ PS=3.7e-05 NRD=0.133562 NRS=0.133562
M6 24 8 10 VDD P L=1.5e-06 W=1.05e-05 AD=1.8375e-11 AS=3.885e-11 PD=1.4e-05
+ PS=2.84e-05 NRD=0.166667 NRS=0.185714
M7 VDD 9 24 VDD P L=1.5e-06 W=1.05e-05 AD=6.605e-11 AS=1.8375e-11 PD=4.06e-05
+ PS=1.4e-05 NRD=0.22381 NRS=0.166667
M8 OUT1 10 VDD VDD P L=1.5e-06 W=1.6e-05 AD=5.92e-11 AS=6.605e-11 PD=3.94e-05
+ PS=4.06e-05 NRD=0.121875 NRS=0.121875
M9 25 IN1 9 VSS N L=1.2e-06 W=8e-06 AD=1.2e-11 AS=2.96e-11 PD=1.1e-05
+ PS=2.34e-05 NRD=0.1875 NRS=0.24375
M10 26 IN2 25 VSS N L=1.2e-06 W=8e-06 AD=1.2e-11 AS=1.2e-11 PD=1.1e-05
+ PS=1.1e-05 NRD=0.1875 NRS=0.1875
M11 VSS IN3 26 VSS N L=1.2e-06 W=8e-06 AD=4.4e-11 AS=1.2e-11 PD=2.7e-05
+ PS=1.1e-05 NRD=0.26875 NRS=0.1875
M12 27 IN6 VSS VSS N L=1.2e-06 W=8e-06 AD=1.56e-11 AS=4.4e-11 PD=1.19e-05
+ PS=2.7e-05 NRD=0.24375 NRS=0.41875
M13 28 IN5 27 VSS N L=1.2e-06 W=8e-06 AD=5.2e-12 AS=1.56e-11 PD=9.3e-06
+ PS=1.19e-05 NRD=0.08125 NRS=0.24375
M14 8 IN4 28 VSS N L=1.2e-06 W=8e-06 AD=2.96e-11 AS=5.2e-12 PD=2.34e-05
+ PS=9.3e-06 NRD=0.24375 NRS=0.08125
M15 10 8 VSS VSS N L=1.2e-06 W=5e-06 AD=2.3e-11 AS=1.85e-11 PD=1.92e-05
+ PS=1.74e-05 NRD=0.53 NRS=0.39
M16 VSS 9 10 VSS N L=1.2e-06 W=5e-06 AD=3.21e-11 AS=2.3e-11 PD=2.44e-05
+ PS=1.92e-05 NRD=0.4 NRS=0.39
M17 OUT1 10 VSS VSS N L=1.2e-06 W=8e-06 AD=2.96e-11 AS=3.21e-11 PD=2.34e-05
+ PS=2.44e-05 NRD=0.24375 NRS=0.24375

.ends
*
* Design:   NND701
* Created:  "Fri Apr 10 21:12:19 2026"
* Vendor:   "Siemens"
* Program:  "Calibre xRC"
* Version:  "v2025.3_28.17"

*
.subckt NND701 IN1 IN2 IN3 IN4 IN7 IN6 IN5 OUT1 VDD VSS
*
*
*

M0 9 IN1 VDD VDD P L=1.5e-06 W=1.35e-05 AD=5.265e-11 AS=4.995e-11 PD=3.48e-05
+ PS=3.44e-05 NRD=0.144444 NRS=0.144444
M1 VDD IN2 9 VDD P L=1.5e-06 W=1.35e-05 AD=5.265e-11 AS=5.265e-11 PD=3.48e-05
+ PS=3.48e-05 NRD=0.144444 NRS=0.144444
M2 9 IN3 VDD VDD P L=1.5e-06 W=1.35e-05 AD=5.265e-11 AS=5.265e-11 PD=3.48e-05
+ PS=3.48e-05 NRD=0.144444 NRS=0.144444
M3 VDD IN4 9 VDD P L=1.5e-06 W=1.35e-05 AD=5.265e-11 AS=5.265e-11 PD=3.48e-05
+ PS=3.48e-05 NRD=0.144444 NRS=0.144444
M4 10 IN7 VDD VDD P L=1.5e-06 W=1.35e-05 AD=5.265e-11 AS=5.265e-11 PD=3.48e-05
+ PS=3.48e-05 NRD=0.144444 NRS=0.144444
M5 VDD IN6 10 VDD P L=1.5e-06 W=1.35e-05 AD=5.265e-11 AS=5.265e-11 PD=3.48e-05
+ PS=3.48e-05 NRD=0.144444 NRS=0.144444
M6 10 IN5 VDD VDD P L=1.5e-06 W=1.35e-05 AD=4.995e-11 AS=5.265e-11 PD=3.44e-05
+ PS=3.48e-05 NRD=0.144444 NRS=0.144444
M7 24 9 11 VDD P L=1.5e-06 W=1.05e-05 AD=1.05e-11 AS=3.885e-11 PD=1.25e-05
+ PS=2.84e-05 NRD=0.0952381 NRS=0.185714
M8 VDD 10 24 VDD P L=1.5e-06 W=1.05e-05 AD=8.801e-11 AS=1.05e-11 PD=5.24e-05
+ PS=1.25e-05 NRD=0.216667 NRS=0.0952381
M9 OUT1 11 VDD VDD P L=1.5e-06 W=1.66e-05 AD=4.644e-11 AS=8.801e-11 PD=3.02e-05
+ PS=5.24e-05 NRD=0.134036 NRS=0.128591
M10 25 IN1 9 VSS N L=1.2e-06 W=7e-06 AD=7e-12 AS=2.59e-11 PD=9e-06 PS=2.14e-05
+ NRD=0.142857 NRS=0.278571
M11 26 IN2 25 VSS N L=1.2e-06 W=7e-06 AD=1.3825e-11 AS=7e-12 PD=1.095e-05
+ PS=9e-06 NRD=0.282143 NRS=0.142857
M12 27 IN3 26 VSS N L=1.2e-06 W=7e-06 AD=1.7675e-11 AS=1.3825e-11 PD=1.205e-05
+ PS=1.095e-05 NRD=0.360714 NRS=0.282143
M13 VSS IN4 27 VSS N L=1.2e-06 W=7e-06 AD=2.73e-11 AS=1.7675e-11 PD=2.18e-05
+ PS=1.205e-05 NRD=0.278571 NRS=0.360714
M14 28 IN7 VSS VSS N L=1.2e-06 W=7e-06 AD=1.785e-11 AS=2.73e-11 PD=1.21e-05
+ PS=2.18e-05 NRD=0.364286 NRS=0.278571
M15 29 IN6 28 VSS N L=1.2e-06 W=7e-06 AD=1.47e-11 AS=1.785e-11 PD=1.12e-05
+ PS=1.21e-05 NRD=0.3 NRS=0.364286
M16 10 IN5 29 VSS N L=1.2e-06 W=7e-06 AD=2.59e-11 AS=1.47e-11 PD=2.14e-05
+ PS=1.12e-05 NRD=0.278571 NRS=0.3
M17 11 9 VSS VSS N L=1.2e-06 W=5e-06 AD=1.95e-11 AS=1.85e-11 PD=1.78e-05
+ PS=1.74e-05 NRD=0.39 NRS=0.39
M18 VSS 10 11 VSS N L=1.2e-06 W=5e-06 AD=2.29e-11 AS=1.95e-11 PD=1.98e-05
+ PS=1.78e-05 NRD=0.39 NRS=0.39
M19 OUT1 11 VSS VSS N L=1.2e-06 W=6e-06 AD=2.25e-11 AS=2.29e-11 PD=1.95e-05
+ PS=1.98e-05 NRD=0.333333 NRS=0.325

.ends
*
* Design:   NOR200
* Created:  "Fri Apr 10 21:14:07 2026"
* Vendor:   "Siemens"
* Program:  "Calibre xRC"
* Version:  "v2025.3_28.17"

*
.subckt NOR200 IN1 IN2 OUT1 VDD VSS
*
*
*

M0 9 IN1 VDD VDD P L=1.5e-06 W=1.9e-05 AD=2.69439e-11 AS=7.03e-11
+ PD=2.52051e-05 PS=4.54e-05 NRD=0.189474 NRS=0.102632
M1 OUT1 IN2 9 VDD P L=1.5e-06 W=1.9e-05 AD=5.106e-11 AS=2.69439e-11 PD=3.5e-05
+ PS=2.52051e-05 NRD=0.108947 NRS=0.15
M2 VSS IN1 OUT1 VSS N L=1.2e-06 W=6.5e-06 AD=2.535e-11 AS=2.405e-11 PD=2.08e-05
+ PS=2.04e-05 NRD=0.3 NRS=0.3
M3 OUT1 IN2 VSS VSS N L=1.2e-06 W=6.5e-06 AD=2.405e-11 AS=2.535e-11 PD=2.04e-05
+ PS=2.08e-05 NRD=0.3 NRS=0.3

.ends
*
* Design:   NOR201
* Created:  "Fri Apr 10 21:14:48 2026"
* Vendor:   "Siemens"
* Program:  "Calibre xRC"
* Version:  "v2025.3_28.17"

*
.subckt NOR201 IN1 IN2 OUT1 VDD VSS
*
*
*

M0 12 IN1 VDD VDD P L=1.5e-06 W=1.5e-05 AD=1.5e-11 AS=5.55e-11 PD=1.7e-05
+ PS=3.74e-05 NRD=0.0666667 NRS=0.13
M1 5 IN2 12 VDD P L=1.5e-06 W=1.5e-05 AD=5.55e-11 AS=1.5e-11 PD=3.74e-05
+ PS=1.7e-05 NRD=0.13 NRS=0.0666667
M2 VDD 5 3 VDD P L=1.5e-06 W=1e-05 AD=6.032e-11 AS=3.7e-11 PD=3.86e-05
+ PS=2.74e-05 NRD=0.208333 NRS=0.195
M3 OUT1 3 VDD VDD P L=1.5e-06 W=1.4e-05 AD=5.46e-11 AS=6.032e-11 PD=3.58e-05
+ PS=3.86e-05 NRD=0.139286 NRS=0.139286
M4 VSS IN1 5 VSS N L=1.2e-06 W=4.95e-06 AD=1.9305e-11 AS=1.8315e-11 PD=1.77e-05
+ PS=1.73e-05 NRD=0.393939 NRS=0.393939
M5 5 IN2 VSS VSS N L=1.2e-06 W=4.95e-06 AD=1.8315e-11 AS=1.9305e-11 PD=1.73e-05
+ PS=1.77e-05 NRD=0.393939 NRS=0.393939
M6 VSS 5 3 VSS N L=1.2e-06 W=5e-06 AD=3.64375e-11 AS=1.875e-11 PD=2.63e-05
+ PS=1.75e-05 NRD=0.46 NRS=0.4
M7 OUT1 3 VSS VSS N L=1.2e-06 W=8.75e-06 AD=3.2375e-11 AS=3.64375e-11
+ PD=2.49e-05 PS=2.63e-05 NRD=0.222857 NRS=0.24

.ends
*
* Design:   NOR300
* Created:  "Fri Apr 10 21:15:24 2026"
* Vendor:   "Siemens"
* Program:  "Calibre xRC"
* Version:  "v2025.3_28.17"

*
.subckt NOR300 IN1 IN2 IN3 OUT1 VDD VSS
*
*
*

M0 10 IN1 VDD VDD P L=1.5e-06 W=2e-05 AD=2e-11 AS=7.4e-11 PD=2.2e-05
+ PS=4.74e-05 NRD=0.05 NRS=0.0975
M1 11 IN2 10 VDD P L=1.5e-06 W=2e-05 AD=3.4188e-11 AS=2e-11 PD=2.86265e-05
+ PS=2.2e-05 NRD=0.2425 NRS=0.05
M2 OUT1 IN3 11 VDD P L=1.5e-06 W=2e-05 AD=6.0835e-11 AS=3.4188e-11 PD=3.8e-05
+ PS=2.86265e-05 NRD=0.1305 NRS=0.205
M3 OUT1 IN1 VSS VSS N L=1.2e-06 W=6e-06 AD=2.34e-11 AS=2.22e-11 PD=1.98e-05
+ PS=1.94e-05 NRD=0.325 NRS=0.325
M4 VSS IN2 OUT1 VSS N L=1.2e-06 W=6e-06 AD=2.34e-11 AS=2.34e-11 PD=1.98e-05
+ PS=1.98e-05 NRD=0.325 NRS=0.325
M5 OUT1 IN3 VSS VSS N L=1.2e-06 W=6e-06 AD=2.22e-11 AS=2.34e-11 PD=1.94e-05
+ PS=1.98e-05 NRD=0.325 NRS=0.325

.ends
*
* Design:   NOR301
* Created:  "Fri Apr 10 21:16:58 2026"
* Vendor:   "Siemens"
* Program:  "Calibre xRC"
* Version:  "v2025.3_28.17"

*
.subckt NOR301 IN3 IN1 IN2 OUT1 VDD VSS
*
*
*

M0 15 IN1 VDD VDD P L=1.5e-06 W=1.6e-05 AD=1.28e-11 AS=5.92e-11 PD=1.76e-05
+ PS=3.94e-05 NRD=0.05 NRS=0.121875
M1 16 IN2 15 VDD P L=1.5e-06 W=1.6e-05 AD=1.28e-11 AS=1.28e-11 PD=1.76e-05
+ PS=1.76e-05 NRD=0.05 NRS=0.05
M2 5 IN3 16 VDD P L=1.5e-06 W=1.6e-05 AD=7.2e-11 AS=1.28e-11 PD=4.1e-05
+ PS=1.76e-05 NRD=0.171875 NRS=0.05
M3 VDD 5 6 VDD P L=1.5e-06 W=7e-06 AD=5.53e-11 AS=2.59e-11 PD=3.64e-05
+ PS=2.14e-05 NRD=0.321429 NRS=0.278571
M4 OUT1 6 VDD VDD P L=1.5e-06 W=1.4e-05 AD=5.18e-11 AS=5.53e-11 PD=3.54e-05
+ PS=3.64e-05 NRD=0.139286 NRS=0.139286
M5 5 IN1 VSS VSS N L=1.2e-06 W=6e-06 AD=2.34e-11 AS=2.22e-11 PD=1.98e-05
+ PS=1.94e-05 NRD=0.325 NRS=0.325
M6 VSS IN2 5 VSS N L=1.2e-06 W=6e-06 AD=2.34e-11 AS=2.34e-11 PD=1.98e-05
+ PS=1.98e-05 NRD=0.325 NRS=0.325
M7 5 IN3 VSS VSS N L=1.2e-06 W=6e-06 AD=2.22e-11 AS=2.34e-11 PD=1.94e-05
+ PS=1.98e-05 NRD=0.325 NRS=0.325
M8 VSS 5 6 VSS N L=1.2e-06 W=4e-06 AD=2.81e-11 AS=1.48e-11 PD=2.25e-05
+ PS=1.54e-05 NRD=0.575 NRS=0.4875
M9 OUT1 6 VSS VSS N L=1.2e-06 W=7e-06 AD=2.59e-11 AS=2.81e-11 PD=2.14e-05
+ PS=2.25e-05 NRD=0.278571 NRS=0.278571

.ends
*
* Design:   NOR401
* Created:  "Fri Apr 10 21:18:59 2026"
* Vendor:   "Siemens"
* Program:  "Calibre xRC"
* Version:  "v2025.3_28.17"

*
.subckt NOR401 IN1 IN2 IN3 IN4 OUT1 VSS VDD
*
*
*

M0 18 IN1 VDD VDD P L=1.5e-06 W=1.6e-05 AD=1.6e-11 AS=5.92e-11 PD=1.8e-05
+ PS=3.94e-05 NRD=0.0625 NRS=0.121875
M1 6 IN2 18 VDD P L=1.5e-06 W=1.6e-05 AD=5.92e-11 AS=1.6e-11 PD=3.94e-05
+ PS=1.8e-05 NRD=0.121875 NRS=0.0625
M2 19 IN3 6 VDD P L=1.5e-06 W=1.6e-05 AD=1.6e-11 AS=5.92e-11 PD=1.8e-05
+ PS=3.94e-05 NRD=0.0625 NRS=0.121875
M3 7 IN4 19 VDD P L=1.5e-06 W=1.6e-05 AD=5.92e-11 AS=1.6e-11 PD=3.94e-05
+ PS=1.8e-05 NRD=0.121875 NRS=0.0625
M4 VDD 7 8 VDD P L=1.5e-06 W=1e-05 AD=5.96e-11 AS=3.7e-11 PD=3.68e-05
+ PS=2.74e-05 NRD=0.245 NRS=0.195
M5 OUT1 8 VDD VDD P L=1.5e-06 W=1.4e-05 AD=5.18e-11 AS=5.96e-11 PD=3.54e-05
+ PS=3.68e-05 NRD=0.139286 NRS=0.139286
M6 VSS IN1 7 VSS N L=1.2e-06 W=5e-06 AD=1.95e-11 AS=1.85e-11 PD=1.78e-05
+ PS=1.74e-05 NRD=0.39 NRS=0.39
M7 7 IN2 VSS VSS N L=1.2e-06 W=5e-06 AD=1.95e-11 AS=1.95e-11 PD=1.78e-05
+ PS=1.78e-05 NRD=0.39 NRS=0.39
M8 VSS IN3 7 VSS N L=1.2e-06 W=5e-06 AD=1.95e-11 AS=1.95e-11 PD=1.78e-05
+ PS=1.78e-05 NRD=0.39 NRS=0.39
M9 7 IN4 VSS VSS N L=1.2e-06 W=5e-06 AD=1.85e-11 AS=1.95e-11 PD=1.74e-05
+ PS=1.78e-05 NRD=0.39 NRS=0.39
M10 VSS 7 8 VSS N L=1.2e-06 W=8e-06 AD=3.12e-11 AS=3.12e-11 PD=2.38e-05
+ PS=2.38e-05 NRD=0.24375 NRS=0.26875
M11 OUT1 8 VSS VSS N L=1.2e-06 W=8e-06 AD=2.96e-11 AS=3.12e-11 PD=2.34e-05
+ PS=2.38e-05 NRD=0.24375 NRS=0.24375

.ends
*
* Design:   NOR501
* Created:  "Fri Apr 10 21:19:26 2026"
* Vendor:   "Siemens"
* Program:  "Calibre xRC"
* Version:  "v2025.3_28.17"

*
.subckt NOR501 IN5 IN4 IN3 IN2 IN1 OUT1 VDD VSS
*
*
*

M0 21 IN5 7 VDD P L=1.5e-06 W=7e-06 AD=7e-12 AS=2.59e-11 PD=9e-06 PS=2.14e-05
+ NRD=0.142857 NRS=0.278571
M1 VDD IN4 21 VDD P L=1.5e-06 W=7e-06 AD=4.05e-11 AS=7e-12 PD=2.84e-05 PS=9e-06
+ NRD=0.321429 NRS=0.142857
M2 8 7 VDD VDD P L=1.5e-06 W=1e-05 AD=3.9e-11 AS=4.05e-11 PD=2.78e-05
+ PS=2.84e-05 NRD=0.195 NRS=0.195
M3 VDD 9 8 VDD P L=1.5e-06 W=1e-05 AD=3.7e-11 AS=3.9e-11 PD=2.74e-05
+ PS=2.78e-05 NRD=0.195 NRS=0.195
M4 22 IN3 9 VDD P L=1.5e-06 W=1.6e-05 AD=1.04e-11 AS=5.92e-11 PD=1.73e-05
+ PS=3.94e-05 NRD=0.040625 NRS=0.121875
M5 23 IN2 22 VDD P L=1.5e-06 W=1.6e-05 AD=1.04e-11 AS=1.04e-11 PD=1.73e-05
+ PS=1.73e-05 NRD=0.040625 NRS=0.040625
M6 VDD IN1 23 VDD P L=1.5e-06 W=1.6e-05 AD=6.24e-11 AS=1.04e-11 PD=3.98e-05
+ PS=1.73e-05 NRD=0.121875 NRS=0.040625
M7 OUT1 8 VDD VDD P L=1.5e-06 W=1.6e-05 AD=5.92e-11 AS=6.24e-11 PD=3.94e-05
+ PS=3.98e-05 NRD=0.121875 NRS=0.121875
M8 7 IN5 VSS VSS N L=1.2e-06 W=3.5e-06 AD=1.365e-11 AS=1.295e-11 PD=1.48e-05
+ PS=1.44e-05 NRD=0.557143 NRS=0.557143
M9 VSS IN4 7 VSS N L=1.2e-06 W=3.5e-06 AD=3.135e-11 AS=1.365e-11 PD=2.44e-05
+ PS=1.48e-05 NRD=0.5 NRS=0.557143
M10 24 7 VSS VSS N L=1.2e-06 W=8e-06 AD=5.2e-12 AS=3.135e-11 PD=9.3e-06
+ PS=2.44e-05 NRD=0.08125 NRS=0.24375
M11 8 9 24 VSS N L=1.2e-06 W=8e-06 AD=2.96e-11 AS=5.2e-12 PD=2.34e-05
+ PS=9.3e-06 NRD=0.24375 NRS=0.08125
M12 VSS IN3 9 VSS N L=1.2e-06 W=6e-06 AD=2.34e-11 AS=2.22e-11 PD=1.98e-05
+ PS=1.94e-05 NRD=0.325 NRS=0.325
M13 9 IN2 VSS VSS N L=1.2e-06 W=6e-06 AD=2.34e-11 AS=2.34e-11 PD=1.98e-05
+ PS=1.98e-05 NRD=0.325 NRS=0.325
M14 VSS IN1 9 VSS N L=1.2e-06 W=6e-06 AD=3.53e-11 AS=2.34e-11 PD=2.64e-05
+ PS=1.98e-05 NRD=0.375 NRS=0.325
M15 OUT1 8 VSS VSS N L=1.2e-06 W=7e-06 AD=2.59e-11 AS=3.53e-11 PD=2.14e-05
+ PS=2.64e-05 NRD=0.278571 NRS=0.278571

.ends
*
* Design:   NOR601
* Created:  "Fri Apr 10 21:21:09 2026"
* Vendor:   "Siemens"
* Program:  "Calibre xRC"
* Version:  "v2025.3_28.17"

*
.subckt NOR601 IN3 IN2 IN1 IN4 IN5 IN6 OUT1 VSS VDD
*
*
*

M0 23 IN3 1 VDD P L=1.5e-06 W=1.4e-05 AD=1.4e-11 AS=5.18e-11 PD=1.6e-05
+ PS=3.54e-05 NRD=0.0714286 NRS=0.139286
M1 24 IN2 23 VDD P L=1.5e-06 W=1.4e-05 AD=1.4e-11 AS=1.4e-11 PD=1.6e-05
+ PS=1.6e-05 NRD=0.0714286 NRS=0.0714286
M2 VDD IN1 24 VDD P L=1.5e-06 W=1.4e-05 AD=5.68e-11 AS=1.4e-11 PD=3.64e-05
+ PS=1.6e-05 NRD=0.139286 NRS=0.0714286
M3 12 1 VDD VDD P L=1.5e-06 W=1e-05 AD=4.55e-11 AS=5.68e-11 PD=2.91e-05
+ PS=3.64e-05 NRD=0.255 NRS=0.195
M4 VDD 6 12 VDD P L=1.5e-06 W=1e-05 AD=4e-11 AS=4.55e-11 PD=2.8e-05 PS=2.91e-05
+ NRD=0.225 NRS=0.26
M5 25 IN4 6 VDD P L=1.5e-06 W=1.4e-05 AD=1.26e-11 AS=5.18e-11 PD=1.58e-05
+ PS=3.54e-05 NRD=0.0642857 NRS=0.139286
M6 26 IN5 25 VDD P L=1.5e-06 W=1.4e-05 AD=1.155e-11 AS=1.26e-11 PD=1.565e-05
+ PS=1.58e-05 NRD=0.0589286 NRS=0.0642857
M7 VDD IN6 26 VDD P L=1.5e-06 W=1.4e-05 AD=6.62e-11 AS=1.155e-11 PD=4.04e-05
+ PS=1.565e-05 NRD=0.160714 NRS=0.0589286
M8 OUT1 12 VDD VDD P L=1.5e-06 W=1.6e-05 AD=5.92e-11 AS=6.62e-11 PD=3.94e-05
+ PS=4.04e-05 NRD=0.121875 NRS=0.121875
M9 VSS IN3 1 VSS N L=1.2e-06 W=8e-06 AD=3.12e-11 AS=2.96e-11 PD=2.38e-05
+ PS=2.34e-05 NRD=0.24375 NRS=0.24375
M10 1 IN2 VSS VSS N L=1.2e-06 W=8e-06 AD=3.12e-11 AS=3.12e-11 PD=2.38e-05
+ PS=2.38e-05 NRD=0.24375 NRS=0.24375
M11 VSS IN1 1 VSS N L=1.2e-06 W=8e-06 AD=5.775e-11 AS=3.12e-11 PD=3.46e-05
+ PS=2.38e-05 NRD=0.30625 NRS=0.24375
M12 27 1 VSS VSS N L=1.2e-06 W=1.25e-05 AD=8.125e-12 AS=5.775e-11 PD=1.38e-05
+ PS=3.46e-05 NRD=0.052 NRS=0.188
M13 12 6 27 VSS N L=1.2e-06 W=1.25e-05 AD=4.625e-11 AS=8.125e-12 PD=3.24e-05
+ PS=1.38e-05 NRD=0.156 NRS=0.052
M14 VSS IN4 6 VSS N L=1.2e-06 W=8e-06 AD=3.12e-11 AS=3.04e-11 PD=2.38e-05
+ PS=2.36e-05 NRD=0.24375 NRS=0.24375
M15 6 IN5 VSS VSS N L=1.2e-06 W=8e-06 AD=3.12e-11 AS=3.12e-11 PD=2.38e-05
+ PS=2.38e-05 NRD=0.24375 NRS=0.24375
M16 VSS IN6 6 VSS N L=1.2e-06 W=8e-06 AD=3.23e-11 AS=3.12e-11 PD=2.42e-05
+ PS=2.38e-05 NRD=0.24375 NRS=0.24375
M17 OUT1 12 VSS VSS N L=1.2e-06 W=7e-06 AD=2.59e-11 AS=3.23e-11 PD=2.14e-05
+ PS=2.42e-05 NRD=0.278571 NRS=0.307143

.ends
*
* Design:   NOR701
* Created:  "Fri Apr 10 21:22:46 2026"
* Vendor:   "Siemens"
* Program:  "Calibre xRC"
* Version:  "v2025.3_28.17"

*
.subckt NOR701 IN1 IN2 IN3 IN4 IN5 IN6 IN7 OUT1 VDD VSS
*
*
*

M0 25 IN1 VDD VDD P L=1.5e-06 W=1.6e-05 AD=1.6e-11 AS=5.92e-11 PD=1.8e-05
+ PS=3.94e-05 NRD=0.0625 NRS=0.121875
M1 10 IN2 25 VDD P L=1.5e-06 W=1.6e-05 AD=5.92e-11 AS=1.6e-11 PD=3.94e-05
+ PS=1.8e-05 NRD=0.121875 NRS=0.0625
M2 26 IN3 10 VDD P L=1.5e-06 W=1.6e-05 AD=1.6e-11 AS=5.92e-11 PD=1.8e-05
+ PS=3.94e-05 NRD=0.0625 NRS=0.121875
M3 11 IN4 26 VDD P L=1.5e-06 W=1.6e-05 AD=5.92e-11 AS=1.6e-11 PD=3.94e-05
+ PS=1.8e-05 NRD=0.121875 NRS=0.0625
M4 27 IN5 VDD VDD P L=1.5e-06 W=1.195e-05 AD=1.195e-11 AS=4.4215e-11
+ PD=1.395e-05 PS=3.13e-05 NRD=0.083682 NRS=0.16318
M5 28 IN6 27 VDD P L=1.5e-06 W=1.195e-05 AD=1.195e-11 AS=1.195e-11 PD=1.395e-05
+ PS=1.395e-05 NRD=0.083682 NRS=0.083682
M6 8 IN7 28 VDD P L=1.5e-06 W=1.195e-05 AD=4.4215e-11 AS=1.195e-11 PD=3.13e-05
+ PS=1.395e-05 NRD=0.16318 NRS=0.083682
M7 12 8 VDD VDD P L=1.5e-06 W=8e-06 AD=3.12e-11 AS=2.96e-11 PD=2.38e-05
+ PS=2.34e-05 NRD=0.24375 NRS=0.24375
M8 VDD 11 12 VDD P L=1.5e-06 W=8e-06 AD=5.95e-11 AS=3.12e-11 PD=3.84e-05
+ PS=2.38e-05 NRD=0.260417 NRS=0.24375
M9 OUT1 12 VDD VDD P L=1.5e-06 W=1.5e-05 AD=5.85e-11 AS=5.95e-11 PD=3.78e-05
+ PS=3.84e-05 NRD=0.13 NRS=0.13
M10 VSS IN1 11 VSS N L=1.2e-06 W=5e-06 AD=1.95e-11 AS=1.85e-11 PD=1.78e-05
+ PS=1.74e-05 NRD=0.39 NRS=0.39
M11 11 IN2 VSS VSS N L=1.2e-06 W=5e-06 AD=1.95e-11 AS=1.95e-11 PD=1.78e-05
+ PS=1.78e-05 NRD=0.39 NRS=0.39
M12 VSS IN3 11 VSS N L=1.2e-06 W=5e-06 AD=1.95e-11 AS=1.95e-11 PD=1.78e-05
+ PS=1.78e-05 NRD=0.39 NRS=0.39
M13 11 IN4 VSS VSS N L=1.2e-06 W=5e-06 AD=1.85e-11 AS=1.95e-11 PD=1.74e-05
+ PS=1.78e-05 NRD=0.39 NRS=0.39
M14 8 IN5 VSS VSS N L=1.2e-06 W=4.05e-06 AD=1.5795e-11 AS=1.4985e-11
+ PD=1.59e-05 PS=1.55e-05 NRD=0.481481 NRS=0.481481
M15 VSS IN6 8 VSS N L=1.2e-06 W=4.05e-06 AD=1.5795e-11 AS=1.5795e-11
+ PD=1.59e-05 PS=1.59e-05 NRD=0.481481 NRS=0.481481
M16 8 IN7 VSS VSS N L=1.2e-06 W=4.05e-06 AD=1.4985e-11 AS=1.5795e-11
+ PD=1.55e-05 PS=1.59e-05 NRD=0.481481 NRS=0.481481
M17 29 8 12 VSS N L=1.2e-06 W=1.005e-05 AD=1.005e-11 AS=3.7185e-11 PD=1.205e-05
+ PS=2.75e-05 NRD=0.0995025 NRS=0.19403
M18 VSS 11 29 VSS N L=1.2e-06 W=1.005e-05 AD=6.9065e-11 AS=1.005e-11
+ PD=3.95e-05 PS=1.205e-05 NRD=0.343284 NRS=0.0995025
M19 OUT1 12 VSS VSS N L=1.2e-06 W=9.5e-06 AD=1.702e-11 AS=6.9065e-11
+ PD=1.66e-05 PS=3.95e-05 NRD=0.205263 NRS=0.236842

.ends
*
* Design:   NOR801
* Created:  "Fri Apr 10 21:24:30 2026"
* Vendor:   "Siemens"
* Program:  "Calibre xRC"
* Version:  "v2025.3_28.17"

*
.subckt NOR801 IN4 IN3 IN2 IN1 OUT1 IN5 IN7 IN6 IN8 VDD VSS
*
*
*

M0 28 IN4 10 VDD P L=1.5e-06 W=1.3e-05 AD=1.3e-11 AS=4.81e-11 PD=1.5e-05
+ PS=3.34e-05 NRD=0.0769231 NRS=0.15
M1 29 IN3 28 VDD P L=1.5e-06 W=1.3e-05 AD=1.3e-11 AS=1.3e-11 PD=1.5e-05
+ PS=1.5e-05 NRD=0.0769231 NRS=0.0769231
M2 30 IN2 29 VDD P L=1.5e-06 W=1.3e-05 AD=1.745e-11 AS=1.3e-11 PD=1.71e-05
+ PS=1.5e-05 NRD=0.157692 NRS=0.0769231
M3 VDD IN1 30 VDD P L=1.5e-06 W=1.3e-05 AD=5.07e-11 AS=1.745e-11 PD=3.38e-05
+ PS=1.71e-05 NRD=0.15 NRS=0.157692
M4 11 10 VDD VDD P L=1.5e-06 W=1.3e-05 AD=5.07e-11 AS=5.07e-11 PD=3.38e-05
+ PS=3.38e-05 NRD=0.15 NRS=0.15
M5 VDD 13 11 VDD P L=1.5e-06 W=1.3e-05 AD=4.81e-11 AS=5.07e-11 PD=3.34e-05
+ PS=3.38e-05 NRD=0.15 NRS=0.15
M6 VDD 11 OUT1 VDD P L=1.5e-06 W=1.8e-05 AD=1.9136e-10 AS=4.787e-11 PD=6.72e-05
+ PS=3.3e-05 NRD=0.135 NRS=0.127222
M7 31 IN5 VDD VDD P L=1.5e-06 W=1.3e-05 AD=1.3e-11 AS=1.9136e-10 PD=1.5e-05
+ PS=6.72e-05 NRD=0.0769231 NRS=0.488095
M8 32 IN6 31 VDD P L=1.5e-06 W=1.3e-05 AD=1.365e-11 AS=1.3e-11 PD=1.51e-05
+ PS=1.5e-05 NRD=0.0807692 NRS=0.0769231
M9 33 IN7 32 VDD P L=1.5e-06 W=1.3e-05 AD=1.235e-11 AS=1.365e-11 PD=1.49e-05
+ PS=1.51e-05 NRD=0.0730769 NRS=0.0807692
M10 13 IN8 33 VDD P L=1.5e-06 W=1.3e-05 AD=4.81e-11 AS=1.235e-11 PD=3.34e-05
+ PS=1.49e-05 NRD=0.15 NRS=0.0730769
M11 10 IN4 VSS VSS N L=1.2e-06 W=5.2e-06 AD=2.028e-11 AS=1.924e-11 PD=1.82e-05
+ PS=1.78e-05 NRD=0.375 NRS=0.375
M12 VSS IN3 10 VSS N L=1.2e-06 W=5.2e-06 AD=2.76e-11 AS=2.028e-11 PD=2.24e-05
+ PS=1.82e-05 NRD=0.336538 NRS=0.375
M13 10 IN2 VSS VSS N L=1.2e-06 W=5.2e-06 AD=4.23e-11 AS=2.76e-11 PD=2.66e-05
+ PS=2.24e-05 NRD=0.5 NRS=0.375
M14 VSS IN1 10 VSS N L=1.2e-06 W=5.2e-06 AD=6.18e-11 AS=4.23e-11 PD=4.04e-05
+ PS=2.66e-05 NRD=0.384615 NRS=0.615385
M15 34 10 VSS VSS N L=1.2e-06 W=1.6e-05 AD=1.36e-11 AS=6.18e-11 PD=1.77e-05
+ PS=4.04e-05 NRD=0.053125 NRS=0.121875
M16 11 13 34 VSS N L=1.2e-06 W=1.6e-05 AD=5.92e-11 AS=1.36e-11 PD=3.94e-05
+ PS=1.77e-05 NRD=0.121875 NRS=0.053125
M17 VSS 11 OUT1 VSS N L=1.2e-06 W=8e-06 AD=3.22e-11 AS=2.96e-11 PD=2.44e-05
+ PS=2.34e-05 NRD=0.24375 NRS=0.24375
M18 13 IN5 VSS VSS N L=1.2e-06 W=5.2e-06 AD=2.028e-11 AS=3.22e-11 PD=1.82e-05
+ PS=2.44e-05 NRD=0.144231 NRS=0.369591
M19 VSS IN6 13 VSS N L=1.2e-06 W=5.2e-06 AD=2.028e-11 AS=2.028e-11 PD=1.82e-05
+ PS=1.82e-05 NRD=0.375 NRS=0.375
M20 13 IN7 VSS VSS N L=1.2e-06 W=5.2e-06 AD=2.028e-11 AS=2.028e-11 PD=1.82e-05
+ PS=1.82e-05 NRD=0.375 NRS=0.375
M21 VSS IN8 13 VSS N L=1.2e-06 W=5.2e-06 AD=1.924e-11 AS=2.028e-11 PD=1.78e-05
+ PS=1.82e-05 NRD=0.375 NRS=0.375

.ends
*
* Design:   OR2101
* Created:  "Fri Apr 10 21:25:14 2026"
* Vendor:   "Siemens"
* Program:  "Calibre xRC"
* Version:  "v2025.3_28.17"

*
.subckt OR2101 IN1 IN2 OUT1 VSS VDD
*
*
*

M0 11 IN1 5 VDD P L=1.5e-06 W=1.4e-05 AD=1.4e-11 AS=5.18e-11 PD=1.6e-05
+ PS=3.54e-05 NRD=0.0714286 NRS=0.139286
M1 VDD IN2 11 VDD P L=1.5e-06 W=1.4e-05 AD=8.7e-11 AS=1.4e-11 PD=4.3e-05
+ PS=1.6e-05 NRD=0.244643 NRS=0.0714286
M2 OUT1 5 VDD VDD P L=1.5e-06 W=1.6e-05 AD=5.92e-11 AS=8.7e-11 PD=3.94e-05
+ PS=4.3e-05 NRD=0.121875 NRS=0.121875
M3 5 IN1 VSS VSS N L=1.2e-06 W=7e-06 AD=2.73e-11 AS=2.59e-11 PD=2.18e-05
+ PS=2.14e-05 NRD=0.278571 NRS=0.278571
M4 VSS IN2 5 VSS N L=1.2e-06 W=7e-06 AD=4.15e-11 AS=2.73e-11 PD=2.8e-05
+ PS=2.18e-05 NRD=0.321429 NRS=0.278571
M5 OUT1 5 VSS VSS N L=1.2e-06 W=9.5e-06 AD=3.515e-11 AS=4.15e-11 PD=2.64e-05
+ PS=2.8e-05 NRD=0.205263 NRS=0.236842

.ends
*
* Design:   OR3101
* Created:  "Fri Apr 10 21:26:19 2026"
* Vendor:   "Siemens"
* Program:  "Calibre xRC"
* Version:  "v2025.3_28.17"

*
.subckt OR3101 IN1 IN2 IN3 OUT1 VDD VSS
*
*
*

M0 13 IN1 1 VDD P L=1.5e-06 W=1.9e-05 AD=1.9e-11 AS=7.03e-11 PD=2.1e-05
+ PS=4.54e-05 NRD=0.0526316 NRS=0.102632
M1 14 IN2 13 VDD P L=1.5e-06 W=1.9e-05 AD=1.71e-11 AS=1.9e-11 PD=2.08e-05
+ PS=2.1e-05 NRD=0.0473684 NRS=0.0526316
M2 VDD IN3 14 VDD P L=1.5e-06 W=1.9e-05 AD=1.586e-10 AS=1.71e-11 PD=5.48e-05
+ PS=2.08e-05 NRD=0.422632 NRS=0.0473684
M3 OUT1 1 VDD VDD P L=1.5e-06 W=1.7e-05 AD=6.29e-11 AS=1.586e-10 PD=4.14e-05
+ PS=5.48e-05 NRD=-0.0264706 NRS=0.169045
M4 VSS IN1 1 VSS N L=1.2e-06 W=8e-06 AD=3.12e-11 AS=2.96e-11 PD=2.38e-05
+ PS=2.34e-05 NRD=0.24375 NRS=0.24375
M5 1 IN2 VSS VSS N L=1.2e-06 W=8e-06 AD=3.12e-11 AS=3.12e-11 PD=2.38e-05
+ PS=2.38e-05 NRD=0.24375 NRS=0.24375
M6 VSS IN3 1 VSS N L=1.2e-06 W=8e-06 AD=8.393e-11 AS=3.12e-11 PD=4.61e-05
+ PS=2.38e-05 NRD=0.34375 NRS=0.24375
M7 OUT1 1 VSS VSS N L=1.2e-06 W=1.2e-05 AD=2.627e-11 AS=8.393e-11 PD=2.16e-05
+ PS=4.61e-05 NRD=0.1625 NRS=0.23041

.ends
*
* Design:   OR4101
* Created:  "Fri Apr 10 21:26:51 2026"
* Vendor:   "Siemens"
* Program:  "Calibre xRC"
* Version:  "v2025.3_28.17"

*
.subckt OR4101 IN4 IN3 IN1 IN2 OUT1 VDD VSS
*
*
*

M0 14 IN4 7 VDD P L=1.5e-06 W=1.7e-05 AD=1.7e-11 AS=6.29e-11 PD=1.9e-05
+ PS=4.14e-05 NRD=0.0588235 NRS=0.114706
M1 15 IN3 14 VDD P L=1.5e-06 W=1.7e-05 AD=1.53e-11 AS=1.7e-11 PD=1.88e-05
+ PS=1.9e-05 NRD=0.0529412 NRS=0.0588235
M2 16 IN2 15 VDD P L=1.5e-06 W=1.7e-05 AD=3.315e-11 AS=1.53e-11 PD=2.09e-05
+ PS=1.88e-05 NRD=0.114706 NRS=0.0529412
M3 VDD IN1 16 VDD P L=1.5e-06 W=1.7e-05 AD=9.2485e-11 AS=3.315e-11 PD=5.48e-05
+ PS=2.09e-05 NRD=0.163529 NRS=0.114706
M4 OUT1 7 VDD VDD P L=1.5e-06 W=1.8e-05 AD=5e-11 AS=9.2485e-11 PD=3.3e-05
+ PS=5.48e-05 NRD=0.147222 NRS=0.109463
M5 7 IN4 VSS VSS N L=1.2e-06 W=6.5e-06 AD=2.535e-11 AS=2.405e-11 PD=2.08e-05
+ PS=2.04e-05 NRD=0.3 NRS=0.3
M6 VSS IN3 7 VSS N L=1.2e-06 W=6.5e-06 AD=2.535e-11 AS=2.535e-11 PD=2.08e-05
+ PS=2.08e-05 NRD=0.3 NRS=0.3
M7 7 IN2 VSS VSS N L=1.2e-06 W=6.5e-06 AD=2.535e-11 AS=2.535e-11 PD=2.08e-05
+ PS=2.08e-05 NRD=0.3 NRS=0.3
M8 VSS IN1 7 VSS N L=1.2e-06 W=6.5e-06 AD=7.4455e-11 AS=2.535e-11 PD=4.53e-05
+ PS=2.08e-05 NRD=0.507692 NRS=0.3
M9 OUT1 7 VSS VSS N L=1.2e-06 W=1.25e-05 AD=3.02325e-11 AS=7.4455e-11
+ PD=2.26e-05 PS=4.53e-05 NRD=0.162667 NRS=0.161947

.ends
*
* Design:   OR5101
* Created:  "Thu Apr 16 12:47:19 2026"
* Vendor:   "Siemens"
* Program:  "Calibre xRC"
* Version:  "v2025.3_28.17"

*
.subckt OR5101 IN1 IN3 IN2 IN5 IN4 OUT1 VDD VSS
*
*
*

M0 23 IN1 1 VDD P L=1.5e-06 W=1.25e-05 AD=1.25e-11 AS=4.625e-11 PD=1.45e-05
+ PS=3.24e-05 NRD=0.08 NRS=0.156
M1 24 IN2 23 VDD P L=1.5e-06 W=1.25e-05 AD=1.125e-11 AS=1.25e-11 PD=1.43e-05
+ PS=1.45e-05 NRD=0.072 NRS=0.08
M2 VDD IN3 24 VDD P L=1.5e-06 W=1.25e-05 AD=5.25e-11 AS=1.125e-11 PD=3.38e-05
+ PS=1.43e-05 NRD=0.172 NRS=0.072
M3 9 1 VDD VDD P L=1.5e-06 W=7.5e-06 AD=3.525e-11 AS=5.25e-11 PD=2.44e-05
+ PS=3.38e-05 NRD=0.26 NRS=0.3
M4 VDD 7 9 VDD P L=1.5e-06 W=7.5e-06 AD=8.07e-11 AS=3.525e-11 PD=3.62e-05
+ PS=2.44e-05 NRD=0.277778 NRS=0.366667
M5 25 IN5 VDD VDD P L=1.5e-06 W=9.5e-06 AD=7.125e-12 AS=8.07e-11 PD=1.1e-05
+ PS=3.62e-05 NRD=0.0789474 NRS=0.668421
M6 7 IN4 25 VDD P L=1.5e-06 W=9.5e-06 AD=3.515e-11 AS=7.125e-12 PD=2.64e-05
+ PS=1.1e-05 NRD=0.205263 NRS=0.0789474
M7 VDD 9 10 VDD P L=1.5e-06 W=1.1e-05 AD=6.285e-11 AS=4.07e-11 PD=3.94e-05
+ PS=2.94e-05 NRD=0.193182 NRS=0.177273
M8 OUT1 10 VDD VDD P L=1.5e-06 W=1.55e-05 AD=5.735e-11 AS=6.285e-11 PD=3.84e-05
+ PS=3.94e-05 NRD=0.125806 NRS=0.125806
M9 VSS IN1 1 VSS N L=1.2e-06 W=8.5e-06 AD=3.315e-11 AS=3.145e-11 PD=2.48e-05
+ PS=2.44e-05 NRD=0.229412 NRS=0.229412
M10 1 IN2 VSS VSS N L=1.2e-06 W=8.5e-06 AD=3.315e-11 AS=3.315e-11 PD=2.48e-05
+ PS=2.48e-05 NRD=0.229412 NRS=0.229412
M11 VSS IN3 1 VSS N L=1.2e-06 W=8.5e-06 AD=3.145e-11 AS=3.315e-11 PD=2.44e-05
+ PS=2.48e-05 NRD=0.229412 NRS=0.229412
M12 26 1 9 VSS N L=1.2e-06 W=5.5e-06 AD=4.125e-12 AS=2.035e-11 PD=7e-06
+ PS=1.84e-05 NRD=0.136364 NRS=0.354545
M13 VSS 7 26 VSS N L=1.2e-06 W=5.5e-06 AD=2.68e-11 AS=4.125e-12 PD=2.14e-05
+ PS=7e-06 NRD=0.363636 NRS=0.136364
M14 7 IN5 VSS VSS N L=1.2e-06 W=6.5e-06 AD=2.535e-11 AS=2.68e-11 PD=2.08e-05
+ PS=2.14e-05 NRD=0.3 NRS=0.3
M15 VSS IN4 7 VSS N L=1.2e-06 W=6.5e-06 AD=2.535e-11 AS=2.535e-11 PD=2.08e-05
+ PS=2.08e-05 NRD=0.3 NRS=0.3
M16 10 9 VSS VSS N L=1.2e-06 W=6.5e-06 AD=2.405e-11 AS=2.535e-11 PD=2.04e-05
+ PS=2.08e-05 NRD=0.3 NRS=0.3
M17 OUT1 10 VSS VSS N L=1.2e-06 W=7.5e-06 AD=2.775e-11 AS=2.775e-11 PD=2.24e-05
+ PS=2.24e-05 NRD=0.26 NRS=0.26

.ends
*

*
* Design:   OR7101
* Created:  "Thu Apr 16 16:55:07 2026"
* Vendor:   "Siemens"
* Program:  "Calibre xRC"
* Version:  "v2025.3_28.17"

*
.subckt OR7101 IN5 IN6 IN7 IN4 IN3 IN2 IN1 OUT1 VDD VSS
*
*
*

M0 28 IN5 11 VDD P L=1.5e-06 W=1.25e-05 AD=1.125e-11 AS=4.625e-11 PD=1.43e-05
+ PS=3.24e-05 NRD=0.072 NRS=0.156
M1 29 IN6 28 VDD P L=1.5e-06 W=1.25e-05 AD=1.0625e-11 AS=1.125e-11 PD=1.42e-05
+ PS=1.43e-05 NRD=0.068 NRS=0.072
M2 VDD IN7 29 VDD P L=1.5e-06 W=1.25e-05 AD=1.302e-10 AS=1.0625e-11 PD=5.14e-05
+ PS=1.42e-05 NRD=0.18 NRS=0.068
M3 30 IN4 VDD VDD P L=1.5e-06 W=1.85e-05 AD=3.6075e-11 AS=1.302e-10 PD=2.24e-05
+ PS=5.14e-05 NRD=0.105405 NRS=0.105405
M4 31 IN3 30 VDD P L=1.5e-06 W=1.85e-05 AD=1.665e-11 AS=3.6075e-11 PD=2.03e-05
+ PS=2.24e-05 NRD=0.0486486 NRS=0.105405
M5 32 IN2 31 VDD P L=1.5e-06 W=1.85e-05 AD=1.5725e-11 AS=1.665e-11 PD=2.02e-05
+ PS=2.03e-05 NRD=0.0459459 NRS=0.0486486
M6 5 IN1 32 VDD P L=1.5e-06 W=1.85e-05 AD=6.845e-11 AS=1.5725e-11 PD=4.44e-05
+ PS=2.02e-05 NRD=0.105405 NRS=0.0459459
M7 VDD 9 14 VDD P L=1.5e-06 W=1.19e-05 AD=7.986e-11 AS=2.479e-11 PD=4.5e-05
+ PS=2.08e-05 NRD=0.226891 NRS=0.163866
M8 9 5 VDD VDD P L=1.5e-06 W=7.5e-06 AD=3e-11 AS=7.986e-11 PD=2.3e-05
+ PS=4.5e-05 NRD=0.273333 NRS=0.26
M9 VDD 11 9 VDD P L=1.5e-06 W=7.5e-06 AD=8.027e-11 AS=3e-11 PD=4.92e-05
+ PS=2.3e-05 NRD=0.277778 NRS=0.26
M10 OUT1 14 VDD VDD P L=1.5e-06 W=1.5e-05 AD=3.626e-11 AS=8.027e-11 PD=2.7e-05
+ PS=4.92e-05 NRD=0.198889 NRS=0.139412
M11 VSS IN5 11 VSS N L=1.2e-06 W=9e-06 AD=3.51e-11 AS=3.33e-11 PD=2.58e-05
+ PS=2.54e-05 NRD=0.216667 NRS=0.216667
M12 11 IN6 VSS VSS N L=1.2e-06 W=9e-06 AD=3.51e-11 AS=3.51e-11 PD=2.58e-05
+ PS=2.58e-05 NRD=0.216667 NRS=0.216667
M13 VSS IN7 11 VSS N L=1.2e-06 W=9e-06 AD=3.51e-11 AS=3.51e-11 PD=2.58e-05
+ PS=2.58e-05 NRD=0.216667 NRS=0.216667
M14 5 IN4 VSS VSS N L=1.2e-06 W=9e-06 AD=3.69e-11 AS=3.51e-11 PD=2.62e-05
+ PS=2.58e-05 NRD=0.216667 NRS=0.216667
M15 VSS IN3 5 VSS N L=1.2e-06 W=9e-06 AD=3.51e-11 AS=3.69e-11 PD=2.58e-05
+ PS=2.62e-05 NRD=0.216667 NRS=0.238889
M16 5 IN2 VSS VSS N L=1.2e-06 W=9e-06 AD=3.51e-11 AS=3.51e-11 PD=2.58e-05
+ PS=2.58e-05 NRD=0.216667 NRS=0.216667
M17 VSS IN1 5 VSS N L=1.2e-06 W=9e-06 AD=3.385e-11 AS=3.51e-11 PD=2.58e-05
+ PS=2.58e-05 NRD=0.216667 NRS=0.216667
M18 33 11 VSS VSS N L=1.2e-06 W=6.5e-06 AD=9.75e-12 AS=3.385e-11 PD=9.5e-06
+ PS=2.58e-05 NRD=0.230769 NRS=0.3
M19 9 5 33 VSS N L=1.2e-06 W=6.5e-06 AD=2.405e-11 AS=9.75e-12 PD=2.04e-05
+ PS=9.5e-06 NRD=0.3 NRS=0.230769
M20 VSS 9 14 VSS N L=1.2e-06 W=6.5e-06 AD=3.1e-11 AS=2.405e-11 PD=2.34e-05
+ PS=2.04e-05 NRD=0.307692 NRS=0.3
M21 OUT1 14 VSS VSS N L=1.2e-06 W=7.5e-06 AD=2.775e-11 AS=3.1e-11 PD=2.24e-05
+ PS=2.34e-05 NRD=0.26 NRS=0.26

.ends
*
* Design:   OR8101
* Created:  "Thu Apr 16 16:57:32 2026"
* Vendor:   "Siemens"
* Program:  "Calibre xRC"
* Version:  "v2025.3_28.17"

*
.subckt OR8101 IN1 IN2 IN3 IN4 IN5 IN6 IN7 IN8 OUT1 VDD VSS
*
*
*

M0 28 IN1 VDD VDD P L=1.5e-06 W=1.8e-05 AD=1.8e-11 AS=6.66e-11 PD=2e-05
+ PS=4.34e-05 NRD=0.0555556 NRS=0.108333
M1 29 IN2 28 VDD P L=1.5e-06 W=1.8e-05 AD=1.8e-11 AS=1.8e-11 PD=2e-05 PS=2e-05
+ NRD=0.0555556 NRS=0.0555556
M2 30 IN3 29 VDD P L=1.5e-06 W=1.8e-05 AD=1.8e-11 AS=1.8e-11 PD=2e-05 PS=2e-05
+ NRD=0.0555556 NRS=0.0555556
M3 10 IN4 30 VDD P L=1.5e-06 W=1.8e-05 AD=6.84e-11 AS=1.8e-11 PD=4.36e-05
+ PS=2e-05 NRD=0.113889 NRS=0.0555556
M4 31 IN5 VDD VDD P L=1.5e-06 W=1.8e-05 AD=1.8e-11 AS=6.66e-11 PD=2e-05
+ PS=4.34e-05 NRD=0.0555556 NRS=0.108333
M5 32 IN6 31 VDD P L=1.5e-06 W=1.8e-05 AD=1.8e-11 AS=1.8e-11 PD=2e-05 PS=2e-05
+ NRD=0.0555556 NRS=0.0555556
M6 33 IN7 32 VDD P L=1.5e-06 W=1.8e-05 AD=1.8e-11 AS=1.8e-11 PD=2e-05 PS=2e-05
+ NRD=0.0555556 NRS=0.0555556
M7 11 IN8 33 VDD P L=1.5e-06 W=1.8e-05 AD=6.84e-11 AS=1.8e-11 PD=4.36e-05
+ PS=2e-05 NRD=0.113889 NRS=0.0555556
M8 VDD 10 12 VDD P L=1.5e-06 W=8e-06 AD=3.2e-11 AS=2.96e-11 PD=2.4e-05
+ PS=2.34e-05 NRD=0.24375 NRS=0.24375
M9 12 11 VDD VDD P L=1.5e-06 W=8e-06 AD=2.96e-11 AS=3.2e-11 PD=2.34e-05
+ PS=2.4e-05 NRD=0.24375 NRS=0.25625
M10 VDD 12 13 VDD P L=1.5e-06 W=1.1e-05 AD=5.09e-11 AS=4.07e-11 PD=3.78e-05
+ PS=2.94e-05 NRD=0.177273 NRS=0.177273
M11 OUT1 13 VDD VDD P L=1.5e-06 W=1.5e-05 AD=5.625e-11 AS=5.09e-11 PD=3.75e-05
+ PS=3.78e-05 NRD=0.13 NRS=0.13
M12 VSS IN1 10 VSS N L=1.2e-06 W=1e-05 AD=3.9e-11 AS=3.7e-11 PD=2.78e-05
+ PS=2.74e-05 NRD=0.195 NRS=0.195
M13 10 IN2 VSS VSS N L=1.2e-06 W=1e-05 AD=3.95e-11 AS=3.9e-11 PD=2.79e-05
+ PS=2.78e-05 NRD=0.195 NRS=0.195
M14 VSS IN3 10 VSS N L=1.2e-06 W=1e-05 AD=3.95e-11 AS=3.95e-11 PD=2.79e-05
+ PS=2.79e-05 NRD=0.195 NRS=0.2
M15 10 IN4 VSS VSS N L=1.2e-06 W=1e-05 AD=3.7e-11 AS=3.95e-11 PD=2.74e-05
+ PS=2.79e-05 NRD=0.195 NRS=0.2
M16 VSS IN5 11 VSS N L=1.2e-06 W=1e-05 AD=3.9e-11 AS=3.7e-11 PD=2.78e-05
+ PS=2.74e-05 NRD=0.195 NRS=0.195
M17 11 IN6 VSS VSS N L=1.2e-06 W=1e-05 AD=3.95e-11 AS=3.9e-11 PD=2.79e-05
+ PS=2.78e-05 NRD=0.195 NRS=0.195
M18 VSS IN7 11 VSS N L=1.2e-06 W=1e-05 AD=3.95e-11 AS=3.95e-11 PD=2.79e-05
+ PS=2.79e-05 NRD=0.195 NRS=0.2
M19 11 IN8 VSS VSS N L=1.2e-06 W=1e-05 AD=3.7e-11 AS=3.95e-11 PD=2.74e-05
+ PS=2.79e-05 NRD=0.195 NRS=0.2
M20 34 10 VSS VSS N L=1.2e-06 W=7e-06 AD=7e-12 AS=2.59e-11 PD=9e-06 PS=2.14e-05
+ NRD=0.142857 NRS=0.278571
M21 12 11 34 VSS N L=1.2e-06 W=7e-06 AD=2.59e-11 AS=7e-12 PD=2.14e-05 PS=9e-06
+ NRD=0.278571 NRS=0.142857
M22 VSS 12 13 VSS N L=1.2e-06 W=6e-06 AD=3.28e-11 AS=2.25e-11 PD=2.78e-05
+ PS=1.95e-05 NRD=0.325 NRS=0.333333
M23 OUT1 13 VSS VSS N L=1.2e-06 W=1e-05 AD=3.7e-11 AS=3.28e-11 PD=2.74e-05
+ PS=2.78e-05 NRD=0.195 NRS=0.195

.ends
*
* Design:   ORND01
* Created:  "Thu Apr 16 12:18:15 2026"
* Vendor:   "Siemens"
* Program:  "Calibre xRC"
* Version:  "v2025.3_28.17"

*

.subckt ORND01 A B C OUT1 VSS VDD
*
*
*

M0 VDD A 7 VDD P L=1.5e-06 W=1.2e-05 AD=4.68e-11 AS=4.8e-11 PD=3.18e-05
+ PS=3.2e-05 NRD=0.1625 NRS=0.1875
M1 7 A VDD VDD P L=1.5e-06 W=1.2e-05 AD=8.44e-11 AS=4.68e-11 PD=4.9e-05
+ PS=3.18e-05 NRD=0.2125 NRS=0.1625
M2 OUT1 B 7 VDD P L=1.5e-06 W=2e-05 AD=7.42e-11 AS=8.44e-11 PD=4.78e-05
+ PS=4.9e-05 NRD=0.0975 NRS=0.0975
M3 VDD C OUT1 VDD P L=1.5e-06 W=1.8e-05 AD=6.66e-11 AS=7.42e-11 PD=4.34e-05
+ PS=4.78e-05 NRD=0.108333 NRS=0.108333
M4 VSS A 6 VSS N L=1.2e-06 W=1.2e-05 AD=4.8e-11 AS=4.44e-11 PD=3.2e-05
+ PS=3.14e-05 NRD=0.170833 NRS=0.1625
M5 6 B VSS VSS N L=1.2e-06 W=1.2e-05 AD=4.7e-11 AS=4.8e-11 PD=3.2e-05
+ PS=3.2e-05 NRD=0.170833 NRS=0.1625
M6 OUT1 C 6 VSS N L=1.2e-06 W=1e-05 AD=3.7e-11 AS=4.7e-11 PD=2.74e-05
+ PS=3.2e-05 NRD=0.195 NRS=0.195

.ends
*
* Design:   TBUF01
* Created:  "Thu Apr 16 14:30:16 2026"
* Vendor:   "Siemens"
* Program:  "Calibre xRC"
* Version:  "v2025.3_28.17"

*
.subckt TBUF01 OUT1 IN1 EN VSS VDD
*
*
*

M0 VDD 5 OUT1 VDD P L=1.5e-06 W=2.025e-05 AD=2.58405e-10 AS=6.0645e-11
+ PD=0.0001345 PS=4.06e-05 NRD=0.55 NRS=0.110117
M1 OUT1 5 VDD VDD P L=1.5e-06 W=4.01e-05 AD=6.474e-11 AS=2.58405e-10 PD=4.1e-05
+ PS=0.0001345 NRD=-0.0173604 NRS=0.0741941
M2 5 IN1 VDD VDD P L=1.5e-06 W=1.89e-05 AD=5.438e-11 AS=2.58405e-10 PD=3.52e-05
+ PS=0.0001345 NRD=0.00396825 NRS=0.152993
M3 6 3 5 VDD P L=1.5e-06 W=8e-06 AD=1.62e-11 AS=5.438e-11 PD=1.66e-05
+ PS=3.52e-05 NRD=0.2375 NRS=0.24375
M4 VDD EN 5 VDD P L=1.5e-06 W=5e-06 AD=1.875e-11 AS=1.84387e-11 PD=1.75e-05
+ PS=1.7195e-05 NRD=0.39 NRS=0.39
M5 VDD EN 3 VDD P L=1.5e-06 W=1.4e-05 AD=5.46e-11 AS=5.18e-11 PD=3.58e-05
+ PS=3.54e-05 NRD=0.139286 NRS=0.139286
M6 OUT1 6 VSS VSS N L=1.2e-06 W=1.11e-05 AD=2.71e-11 AS=1.69842e-10 PD=2.24e-05
+ PS=9.36e-05 NRD=-0.27027 NRS=0.323359
M7 OUT1 6 VSS VSS N L=1.2e-06 W=1.89e-05 AD=2.457e-11 AS=1.69842e-10
+ PD=2.04e-05 PS=9.36e-05 NRD=-0.140212 NRS=0.182073
M8 6 IN1 VSS VSS N L=1.2e-06 W=1.43e-05 AD=5.2405e-11 AS=1.69842e-10
+ PD=3.39e-05 PS=9.36e-05 NRD=0.0524476 NRS=0.24228
M9 5 EN 6 VSS N L=1.2e-06 W=7.2e-06 AD=1.4125e-11 AS=5.2405e-11 PD=1.55e-05
+ PS=3.39e-05 NRD=0.256944 NRS=0.270833
M10 VSS 3 6 VSS N L=1.2e-06 W=5e-06 AD=1.85e-11 AS=1.842e-11 PD=1.74e-05
+ PS=1.71657e-05 NRD=0.39 NRS=0.39
M11 VSS EN 3 VSS N L=1.2e-06 W=7e-06 AD=2.625e-11 AS=2.73e-11 PD=2.15e-05
+ PS=2.18e-05 NRD=0.285714 NRS=0.3

.ends
*
* Design:   TINV01
* Created:  "Thu Apr 16 14:35:42 2026"
* Vendor:   "Siemens"
* Program:  "Calibre xRC"
* Version:  "v2025.3_28.17"

*
.subckt TINV01 EN IN1 OUT1 VSS VDD
*
*
*

M0 VDD EN 4 VDD P L=1.5e-06 W=1.2e-05 AD=1.04315e-10 AS=4.44e-11 PD=6.12284e-05
+ PS=3.14e-05 NRD=0.191667 NRS=0.1625
M1 11 IN1 VDD VDD P L=1.5e-06 W=2.175e-05 AD=1.69563e-11 AS=1.04315e-10
+ PD=2.349e-05 PS=6.12284e-05 NRD=0 NRS=0.0943083
M2 OUT1 4 11 VDD P L=1.5e-06 W=1.575e-05 AD=3.97175e-11 AS=1.22787e-11
+ PD=2.85e-05 PS=1.701e-05 NRD=0.128571 NRS=0.0952381
M3 VSS EN 4 VSS N L=1.2e-06 W=6e-06 AD=7.826e-11 AS=2.22e-11 PD=4.88e-05
+ PS=1.94e-05 NRD=0.3375 NRS=0.325
M4 12 IN1 VSS VSS N L=1.2e-06 W=1.52e-05 AD=1.44588e-11 AS=7.826e-11
+ PD=1.75868e-05 PS=4.88e-05 NRD=0 NRS=0.128289
M5 OUT1 EN 12 VSS N L=1.2e-06 W=9e-06 AD=1.517e-11 AS=8.56116e-12 PD=1.56e-05
+ PS=1.04132e-05 NRD=0.216667 NRS=0.211111

.ends
*
* Design:   VDDCON
* Created:  "Fri Apr 10 21:35:51 2026"
* Vendor:   "Siemens"
* Program:  "Calibre xRC"
* Version:  "v2025.3_28.17"

*
.subckt VDDCON VDD VSS
*
*
*

.ends
*
* Design:   VSSCON
* Created:  "Fri Apr 10 21:36:40 2026"
* Vendor:   "Siemens"
* Program:  "Calibre xRC"
* Version:  "v2025.3_28.17"

*
.subckt VSSCON VSS VDD
*
*
*

.ends
*
* Design:   XNR201
* Created:  "Thu Apr 16 12:14:46 2026"
* Vendor:   "Siemens"
* Program:  "Calibre xRC"
* Version:  "v2025.3_28.17"

*
.subckt XNR201 IN1 IN2 OUT1 VSS VDD
*
*
*

M0 14 IN2 4 VDD P L=1.5e-06 W=1.5e-05 AD=1.5e-11 AS=5.55e-11 PD=1.7e-05
+ PS=3.74e-05 NRD=0.0666667 NRS=0.13
M1 VDD IN1 14 VDD P L=1.5e-06 W=1.5e-05 AD=5.85e-11 AS=1.5e-11 PD=3.78e-05
+ PS=1.7e-05 NRD=0.13 NRS=0.0666667
M2 15 IN1 VDD VDD P L=1.5e-06 W=1.5e-05 AD=1.345e-11 AS=5.85e-11 PD=1.6625e-05
+ PS=3.78e-05 NRD=0.386667 NRS=0.13
M3 VDD IN2 15 VDD P L=1.5e-06 W=1.5e-05 AD=4.25e-11 AS=1.345e-11 PD=2.7e-05
+ PS=1.6625e-05 NRD=0.184444 NRS=0.336667
M4 5 4 15 VDD P L=1.5e-06 W=1.5e-05 AD=3.625e-11 AS=1.345e-11 PD=2.7e-05
+ PS=1.6625e-05 NRD=0.133333 NRS=0.336667
M5 OUT1 5 VDD VDD P L=1.5e-06 W=1.6e-05 AD=5.92e-11 AS=5.92e-11 PD=3.94e-05
+ PS=3.94e-05 NRD=0.121875 NRS=0.121875
M6 4 IN2 VSS VSS N L=1.2e-06 W=5e-06 AD=1.95e-11 AS=1.85e-11 PD=1.78e-05
+ PS=1.74e-05 NRD=0.39 NRS=0.39
M7 VSS IN1 4 VSS N L=1.2e-06 W=5e-06 AD=1.95e-11 AS=1.95e-11 PD=1.78e-05
+ PS=1.78e-05 NRD=0.39 NRS=0.39
M8 5 4 VSS VSS N L=1.2e-06 W=5e-06 AD=1.95e-11 AS=1.95e-11 PD=1.78e-05
+ PS=1.78e-05 NRD=0.39 NRS=0.39
M9 16 IN2 5 VSS N L=1.2e-06 W=5e-06 AD=6.5e-12 AS=1.95e-11 PD=7.6e-06
+ PS=1.78e-05 NRD=0.26 NRS=0.39
M10 VSS IN1 16 VSS N L=1.2e-06 W=5e-06 AD=3.21e-11 AS=6.5e-12 PD=2.44e-05
+ PS=7.6e-06 NRD=0.4 NRS=0.26
M11 OUT1 5 VSS VSS N L=1.2e-06 W=8e-06 AD=2.96e-11 AS=3.21e-11 PD=2.34e-05
+ PS=2.44e-05 NRD=0.24375 NRS=0.24375

.ends
*
* Design:   XOR201
* Created:  "Thu Apr 16 13:05:36 2026"
* Vendor:   "Siemens"
* Program:  "Calibre xRC"
* Version:  "v2025.3_28.17"

*
.subckt XOR201 IN1 IN2 OUT1 VSS VDD
*
*
*

M0 5 IN2 VDD VDD P L=1.5e-06 W=8e-06 AD=3.12e-11 AS=2.96e-11 PD=2.38e-05
+ PS=2.34e-05 NRD=0.24375 NRS=0.24375
M1 VDD IN1 5 VDD P L=1.5e-06 W=8e-06 AD=5.025e-11 AS=3.12e-11 PD=3.34e-05
+ PS=2.38e-05 NRD=0.260417 NRS=0.24375
M2 6 5 VDD VDD P L=1.5e-06 W=1.25e-05 AD=5.25e-11 AS=5.025e-11 PD=3.34e-05
+ PS=3.34e-05 NRD=0.18 NRS=0.156
M3 15 IN1 6 VDD P L=1.5e-06 W=1.25e-05 AD=1.0625e-11 AS=5.25e-11 PD=1.42e-05
+ PS=3.34e-05 NRD=0.068 NRS=0.156
M4 VDD IN2 15 VDD P L=1.5e-06 W=1.25e-05 AD=9.243e-11 AS=1.0625e-11 PD=5.5e-05
+ PS=1.42e-05 NRD=0.233 NRS=0.068
M5 OUT1 6 VDD VDD P L=1.5e-06 W=1.8e-05 AD=4.736e-11 AS=9.243e-11 PD=3.3e-05
+ PS=5.5e-05 NRD=0.148611 NRS=0.113928
M6 16 IN2 5 VSS N L=1.2e-06 W=8e-06 AD=8e-12 AS=2.96e-11 PD=1e-05 PS=2.34e-05
+ NRD=0.125 NRS=0.24375
M7 VSS IN1 16 VSS N L=1.2e-06 W=8e-06 AD=3.16e-11 AS=8e-12 PD=2.44e-05 PS=1e-05
+ NRD=0.24375 NRS=0.125
M8 3 IN1 VSS VSS N L=1.2e-06 W=4e-06 AD=3.16e-11 AS=3.16e-11 PD=2.44e-05
+ PS=2.44e-05 NRD=0.5625 NRS=0.5625
M9 6 5 3 VSS N L=1.2e-06 W=8e-06 AD=2.96e-11 AS=3.16e-11 PD=2.34e-05
+ PS=2.44e-05 NRD=0.24375 NRS=0.24375
M10 VSS IN2 3 VSS N L=1.2e-06 W=4.5e-06 AD=3.185e-11 AS=1.665e-11 PD=2.44e-05
+ PS=1.64e-05 NRD=0.5 NRS=0.433333
M11 OUT1 6 VSS VSS N L=1.2e-06 W=8e-06 AD=2.96e-11 AS=3.185e-11 PD=2.34e-05
+ PS=2.44e-05 NRD=0.24375 NRS=0.24375

.ends
*

*

*

* cell ADNR01
.subckt ADNR01 A B C OUT1 VDD VSS

* device instance $1 r0 *1 6.45,9.25 N
M$1 \$8 B VSS VSS N L=1.2U W=15.5U AS=57.35P AD=34P PS=38.4U PD=20U
* device instance $2 r0 *1 12.15,11 N
M$2 OUT1 A \$8 VSS N L=1.2U W=12U AS=34P AD=22.9P PS=20U PD=15.9U
* device instance $3 r0 *1 17.25,12 N
M$3 VSS C OUT1 VSS N L=1.2U W=10U AS=22.9P AD=37P PS=15.9U PD=27.4U
* device instance $4 r0 *1 19.4,33.5 P
M$4 OUT1 C \$5 VDD P L=1.5U W=19U AS=56.575P AD=70.3P PS=25.4U PD=45.4U
* device instance $5 r0 *1 4.45,34.725 P
M$5 VDD B \$5 VDD P L=1.5U W=24.25U AS=70.485P AD=68.87P PS=45.5U PD=38.15U
* device instance $6 r0 *1 13.5,34.725 P
M$6 VDD A \$5 VDD P L=1.5U W=23.55U AS=56.575P AD=68.87P PS=25.4U PD=38.15U
.ENDS ADNR01

*

* File: BPD220.pex.netlist
* Created: Tue Aug 11 12:45:08 2026
* Program "Calibre xRC"
* Version "v2017.2_16.14"
*
.subckt BPD220 VSS PAD P_EN N_EN VDD TO_CORE
M0 VDD P_EN PAD VDD P L=1.8e-06 W=8.15e-05 AD=3.1785e-10 AS=3.097e-10
+ PD=0.0001708 PS=0.0001706 NRD=0.0239264 NRS=0.0251534
M1 PAD P_EN VDD VDD P L=1.8e-06 W=8.15e-05 AD=3.1785e-10 AS=3.1785e-10
+ PD=0.0001708 PS=0.0001708 NRD=0.0239264 NRS=0.0239264
M2 VDD P_EN PAD VDD P L=1.8e-06 W=8.15e-05 AD=5.738e-10 AS=3.1785e-10
+ PD=0.0001774 PS=0.0001708 NRD=0.0239264 NRS=0.0239264
M3 PAD P_EN VDD VDD P L=1.8e-06 W=5.55e-05 AD=3.7185e-10 AS=5.738e-10
+ PD=0.0001244 PS=0.0001774 NRD=0.0351351 NRS=0.04004
M4 TO_CORE 10 VDD VDD P L=1.5e-06 W=2e-05 AD=7.8e-11 AS=7.4e-11 PD=4.78e-05
+ PS=4.74e-05 NRD=0.0975 NRS=0.0975
M5 TO_CORE 10 VDD VDD P L=1.5e-06 W=2e-05 AD=7.8e-11 AS=7.8e-11 PD=4.78e-05
+ PS=4.78e-05 NRD=0.0975 NRS=0.0975
M6 TO_CORE 10 VDD VDD P L=1.5e-06 W=2e-05 AD=7.4e-11 AS=7.8e-11 PD=4.74e-05
+ PS=4.78e-05 NRD=0.0975 NRS=0.0975
M7 8 3 VDD VDD P L=2.5e-06 W=1.5e-05 AD=5.85e-11 AS=5.55e-11 PD=3.78e-05
+ PS=3.74e-05 NRD=0.13 NRS=0.13
M8 VDD 3 8 VDD P L=2.5e-06 W=1.5e-05 AD=5.85e-11 AS=5.85e-11 PD=3.78e-05
+ PS=3.78e-05 NRD=0.13 NRS=0.13
M9 VDD 3 8 VDD P L=2.5e-06 W=1.5e-05 AD=5.85e-11 AS=5.85e-11 PD=3.78e-05
+ PS=3.78e-05 NRD=0.13 NRS=0.13
M10 VSS 10 8 VDD P L=2.5e-06 W=1.5e-05 AD=5.85e-11 AS=5.85e-11 PD=3.78e-05
+ PS=3.78e-05 NRD=0.13 NRS=0.13
M11 VSS 10 8 VDD P L=2.5e-06 W=1.5e-05 AD=5.85e-11 AS=5.85e-11 PD=3.78e-05
+ PS=3.78e-05 NRD=0.13 NRS=0.13
M12 VSS 10 8 VDD P L=2.5e-06 W=1.5e-05 AD=5.85e-11 AS=5.85e-11 PD=3.78e-05
+ PS=3.78e-05 NRD=0.13 NRS=0.13
M13 VSS 10 8 VDD P L=2.5e-06 W=1.5e-05 AD=5.85e-11 AS=5.85e-11 PD=3.78e-05
+ PS=3.78e-05 NRD=0.13 NRS=0.13
M14 VSS 10 8 VDD P L=2.5e-06 W=1.5e-05 AD=5.85e-11 AS=5.85e-11 PD=3.78e-05
+ PS=3.78e-05 NRD=0.13 NRS=0.13
M15 VSS 10 8 VDD P L=2.5e-06 W=1.5e-05 AD=5.85e-11 AS=8.15e-11 PD=3.78e-05
+ PS=4.84e-05 NRD=0.13 NRS=0.15
M16 10 3 8 VDD P L=2.5e-06 W=2e-05 AD=7.8e-11 AS=8.15e-11 PD=4.78e-05
+ PS=4.84e-05 NRD=0.0975 NRS=0.0975
M17 10 3 8 VDD P L=2.5e-06 W=2e-05 AD=7.8e-11 AS=7.8e-11 PD=4.78e-05 PS=4.78e-05
+ NRD=0.0975 NRS=0.0975
M18 10 3 8 VDD P L=2.5e-06 W=2e-05 AD=7.8e-11 AS=7.8e-11 PD=4.78e-05 PS=4.78e-05
+ NRD=0.0975 NRS=0.0975
M19 10 3 8 VDD P L=2.5e-06 W=2e-05 AD=7.8e-11 AS=7.4e-11 PD=4.78e-05 PS=4.74e-05
+ NRD=0.0975 NRS=0.0975
M20 VSS N_EN PAD VSS N L=1.5e-06 W=6.9e-05 AD=4.761e-10 AS=4.623e-10
+ PD=0.0001518 PS=0.0001514 NRD=0.036166 NRS=0.0282609
M21 PAD N_EN VSS VSS N L=1.5e-06 W=6.9e-05 AD=4.968e-10 AS=4.761e-10
+ PD=0.0001524 PS=0.0001518 NRD=0.0394737 NRS=0.0381423
M22 VSS N_EN PAD VSS N L=1.5e-06 W=6.9e-05 AD=4.761e-10 AS=4.968e-10
+ PD=0.0001518 PS=0.0001524 NRD=0.0381423 NRS=0.0374142
M23 PAD N_EN VSS VSS N L=1.5e-06 W=6.9e-05 AD=4.623e-10 AS=4.761e-10
+ PD=0.0001514 PS=0.0001518 NRD=0.0282609 NRS=0.0381423
M24 VSS 10 TO_CORE VSS N L=1.2e-06 W=1.75e-05 AD=6.825e-11 AS=6.475e-11
+ PD=4.28e-05 PS=4.24e-05 NRD=0.111429 NRS=0.111429
M25 VSS 10 TO_CORE VSS N L=1.2e-06 W=1.75e-05 AD=6.825e-11 AS=6.475e-11
+ PD=4.28e-05 PS=4.24e-05 NRD=0.111429 NRS=0.111429
M26 10 3 7 VSS N L=2e-06 W=2e-05 AD=7.8e-11 AS=7.4e-11 PD=4.78e-05 PS=4.74e-05
+ NRD=0.0975 NRS=0.0975
M27 10 3 7 VSS N L=2e-06 W=2e-05 AD=7.8e-11 AS=8.275e-11 PD=4.78e-05 PS=4.84e-05
+ NRD=0.0975 NRS=0.0975
M28 7 10 VDD VSS N L=2e-06 W=1.75e-05 AD=8.275e-11 AS=6.825e-11 PD=4.84e-05
+ PS=4.28e-05 NRD=0.122857 NRS=0.111429
M29 7 10 VDD VSS N L=2e-06 W=1.75e-05 AD=1.1975e-10 AS=6.825e-11 PD=6.84e-05
+ PS=4.28e-05 NRD=0.122857 NRS=0.111429
M30 VSS 3 7 VSS N L=2e-06 W=3e-05 AD=1.12242e-10 AS=1.1975e-10 PD=6.74e-05
+ PS=6.84e-05 NRD=0.0887037 NRS=0.0704167
*R31 PAD 3 686.333
XR0 PAD 3 RNW W=45u L=14.5u
D32 VSS PAD DNWELLPSUB  AREA=0.207105
D33 PAD VDD DPDIFFNWELL  AREA=0.0104896
D34 3 VDD DPDIFFNWELL  AREA=0.00302336
D35 VSS 3 DNDIFFPSUB  AREA=0.0154093
.ends
*
*
* File: BPD22D.sp
* Created: Wed Apr 29 12:58:26 2026
* Program "Calibre xRC"
* Version "v2017.2_16.14"
*
.subckt BPD22D VSS PAD TO_CORE P_EN N_EN VDD
M0 VDD 3 4 VDD P L=3e-06 W=3.4e-05 AD=1.5935e-10 AS=1.258e-10 PD=8.18e-05
+ PS=7.54e-05 NRD=0.0720588 NRS=0.0573529
M1 TO_CORE 4 VDD VDD P L=1.5e-06 W=3.65e-05 AD=1.4235e-10 AS=1.5935e-10
+ PD=8.08e-05 PS=8.18e-05 NRD=0.0534247 NRS=0.0534247
M2 VDD 4 TO_CORE VDD P L=1.5e-06 W=3.65e-05 AD=1.3505e-10 AS=1.4235e-10
+ PD=8.04e-05 PS=8.08e-05 NRD=0.0534247 NRS=0.0534247
M3 PAD P_EN VDD VDD P L=1.8e-06 W=6.5e-05 AD=2.535e-10 AS=2.405e-10 PD=0.0001378
+ PS=0.0001374 NRD=0.03 NRS=0.03
M4 VDD P_EN PAD VDD P L=1.8e-06 W=6.5e-05 AD=2.535e-10 AS=2.535e-10 PD=0.0001378
+ PS=0.0001378 NRD=0.03 NRS=0.03
M5 PAD P_EN VDD VDD P L=1.8e-06 W=6.5e-05 AD=2.535e-10 AS=2.535e-10 PD=0.0001378
+ PS=0.0001378 NRD=0.03 NRS=0.03
M6 VDD P_EN PAD VDD P L=1.8e-06 W=6.5e-05 AD=2.73e-10 AS=2.535e-10 PD=0.0001384
+ PS=0.0001378 NRD=0.03 NRS=0.03
M7 VSS 3 4 VSS N L=3e-06 W=1.9e-05 AD=1.9515e-10 AS=7.03e-11 PD=0.0001029
+ PS=4.54e-05 NRD=0.128947 NRS=0.102632
M8 TO_CORE 4 VSS VSS N L=1.2e-06 W=4.7e-05 AD=1.739e-10 AS=1.9515e-10
+ PD=0.0001014 PS=0.0001029 NRD=0.0414894 NRS=0.0425532
M9 VSS N_EN PAD VSS N L=1.5e-06 W=6.67e-05 AD=2.6013e-10 AS=2.4679e-10
+ PD=0.0001412 PS=0.0001408 NRD=0.0292354 NRS=0.0292354
M10 PAD N_EN VSS VSS N L=1.5e-06 W=6.67e-05 AD=2.6013e-10 AS=2.6013e-10
+ PD=0.0001412 PS=0.0001412 NRD=0.0292354 NRS=0.0292354
M11 VSS N_EN PAD VSS N L=1.5e-06 W=6.67e-05 AD=2.4679e-10 AS=2.6013e-10
+ PD=0.0001408 PS=0.0001412 NRD=0.0292354 NRS=0.0292354
M12 PAD VDD VSS VSS N L=7e-06 W=2.5e-06 AD=5.00075e-11 AS=1.35e-11 PD=3.06e-05
+ PS=1.5e-05 NRD=0.3 NRS=0.6
*R13 PAD 3 686.333
XR0 PAD 3 RNW W=45u L=14.5u
D14 VSS PAD DNWELLPSUB  AREA=0.207105
D15 PAD VDD DPDIFFNWELL  AREA=0.0104896
D16 3 VDD DPDIFFNWELL  AREA=0.00302336
D17 VSS 3 DNDIFFPSUB  AREA=0.0154093
.ends
*
*
* File: BPD22U.sp
* Created: Wed Apr 29 12:58:28 2026
* Program "Calibre xRC"
* Version "v2017.2_16.14"
*
.subckt BPD22U VSS PAD TO_CORE P_EN N_EN VDD
M0 VDD 3 4 VDD P L=3e-06 W=3.4e-05 AD=1.5935e-10 AS=1.258e-10 PD=8.18e-05
+ PS=7.54e-05 NRD=0.0720588 NRS=0.0573529
M1 PAD VSS VDD VDD P L=3e-06 W=2.5e-06 AD=1.22975e-10 AS=1.5375e-11 PD=4.83e-05
+ PS=1.65e-05 NRD=0.3 NRS=0.518182
M2 TO_CORE 4 VDD VDD P L=1.5e-06 W=3.65e-05 AD=1.4235e-10 AS=1.5935e-10
+ PD=8.08e-05 PS=8.18e-05 NRD=0.0534247 NRS=0.0534247
M3 VDD 4 TO_CORE VDD P L=1.5e-06 W=3.65e-05 AD=1.3505e-10 AS=1.4235e-10
+ PD=8.04e-05 PS=8.08e-05 NRD=0.0534247 NRS=0.0534247
M4 PAD P_EN VDD VDD P L=1.8e-06 W=6.5e-05 AD=2.535e-10 AS=2.405e-10 PD=0.0001378
+ PS=0.0001374 NRD=0.03 NRS=0.03
M5 VDD P_EN PAD VDD P L=1.8e-06 W=6.5e-05 AD=2.535e-10 AS=2.535e-10 PD=0.0001378
+ PS=0.0001378 NRD=0.03 NRS=0.03
M6 PAD P_EN VDD VDD P L=1.8e-06 W=6.5e-05 AD=2.535e-10 AS=2.535e-10 PD=0.0001378
+ PS=0.0001378 NRD=0.03 NRS=0.03
M7 VDD P_EN PAD VDD P L=1.8e-06 W=6.5e-05 AD=2.73e-10 AS=2.535e-10 PD=0.0001384
+ PS=0.0001378 NRD=0.03 NRS=0.03
M8 VSS 3 4 VSS N L=3e-06 W=1.5e-05 AD=1.7735e-10 AS=5.55e-11 PD=9.49e-05
+ PS=3.74e-05 NRD=0.163333 NRS=0.13
M9 TO_CORE 4 VSS VSS N L=1.2e-06 W=4.3e-05 AD=1.591e-10 AS=1.7735e-10
+ PD=9.34e-05 PS=9.49e-05 NRD=0.0453488 NRS=0.0465116
M10 VSS N_EN PAD VSS N L=1.5e-06 W=6.67e-05 AD=2.6013e-10 AS=2.4679e-10
+ PD=0.0001412 PS=0.0001408 NRD=0.0292354 NRS=0.0292354
M11 PAD N_EN VSS VSS N L=1.5e-06 W=6.67e-05 AD=2.6013e-10 AS=2.6013e-10
+ PD=0.0001412 PS=0.0001412 NRD=0.0292354 NRS=0.0292354
M12 VSS N_EN PAD VSS N L=1.5e-06 W=6.67e-05 AD=2.4679e-10 AS=2.6013e-10
+ PD=0.0001408 PS=0.0001412 NRD=0.0292354 NRS=0.0292354
*R13 PAD 3 686.333
XR0 PAD 3 RNW W=45u L=14.5u
D14 VSS PAD DNWELLPSUB  AREA=0.207105
D15 PAD VDD DPDIFFNWELL  AREA=0.0104896
D16 3 VDD DPDIFFNWELL  AREA=0.00302336
D17 VSS 3 DNDIFFPSUB  AREA=0.0154093
.ends
*
*
* File: BPD240.sp
* Created: Wed Apr 29 12:58:29 2026
* Program "Calibre xRC"
* Version "v2017.2_16.14"
*
.subckt BPD240 VSS PAD TO_CORE P_EN N_EN VDD
M0 VDD 3 4 VDD P L=3e-06 W=3.4e-05 AD=1.5935e-10 AS=1.258e-10 PD=8.18e-05
+ PS=7.54e-05 NRD=0.0720588 NRS=0.0573529
M1 TO_CORE 4 VDD VDD P L=1.5e-06 W=3.65e-05 AD=1.4235e-10 AS=1.5935e-10
+ PD=8.08e-05 PS=8.18e-05 NRD=0.0534247 NRS=0.0534247
M2 VDD 4 TO_CORE VDD P L=1.5e-06 W=3.65e-05 AD=1.3505e-10 AS=1.4235e-10
+ PD=8.04e-05 PS=8.08e-05 NRD=0.0534247 NRS=0.0534247
M3 VDD P_EN PAD VDD P L=1.8e-06 W=6.5e-05 AD=2.535e-10 AS=2.405e-10 PD=0.0001378
+ PS=0.0001374 NRD=0.03 NRS=0.03
M4 PAD P_EN VDD VDD P L=1.8e-06 W=6.5e-05 AD=2.535e-10 AS=2.535e-10 PD=0.0001378
+ PS=0.0001378 NRD=0.03 NRS=0.03
M5 VDD P_EN PAD VDD P L=1.8e-06 W=6.5e-05 AD=2.535e-10 AS=2.535e-10 PD=0.0001378
+ PS=0.0001378 NRD=0.03 NRS=0.03
M6 PAD P_EN VDD VDD P L=1.8e-06 W=6.5e-05 AD=2.735e-10 AS=2.535e-10 PD=0.0001388
+ PS=0.0001378 NRD=0.03 NRS=0.03
M7 VDD P_EN PAD VDD P L=1.8e-06 W=4e-05 AD=1.48e-10 AS=2.735e-10 PD=8.74e-05
+ PS=0.0001388 NRD=0.04875 NRS=0.06125
M8 VSS 3 4 VSS N L=3e-06 W=1.7e-05 AD=1.7835e-10 AS=6.29e-11 PD=9.49e-05
+ PS=4.14e-05 NRD=0.139216 NRS=0.114706
M9 TO_CORE 4 VSS VSS N L=1.2e-06 W=4.3e-05 AD=1.591e-10 AS=1.7835e-10
+ PD=9.34e-05 PS=9.49e-05 NRD=0.0453488 NRS=0.0465116
M10 VSS N_EN PAD VSS N L=1.5e-06 W=6.665e-05 AD=2.59935e-10 AS=2.46605e-10
+ PD=0.0001411 PS=0.0001407 NRD=0.0292573 NRS=0.0292573
M11 PAD N_EN VSS VSS N L=1.5e-06 W=6.665e-05 AD=2.59935e-10 AS=2.59935e-10
+ PD=0.0001411 PS=0.0001411 NRD=0.0292573 NRS=0.0292573
M12 VSS N_EN PAD VSS N L=1.5e-06 W=6.665e-05 AD=3.21705e-10 AS=2.59935e-10
+ PD=0.0001695 PS=0.0001411 NRD=0.0329249 NRS=0.0292573
M13 PAD N_EN VSS VSS N L=1.5e-06 W=7.5e-05 AD=2.72135e-10 AS=3.21705e-10
+ PD=0.000147 PS=0.0001695 NRD=0.0262807 NRS=0.0276358
*R14 PAD 3 686.333
XR0 PAD 3 RNW W=45u L=14.5u
D15 VSS PAD DNWELLPSUB  AREA=0.207105
D16 PAD VDD DPDIFFNWELL  AREA=0.0104896
D17 3 VDD DPDIFFNWELL  AREA=0.00302336
D18 VSS 3 DNDIFFPSUB  AREA=0.0154093
.ends
*
*
* File: BPD24D.sp
* Created: Wed Apr 29 12:58:31 2026
* Program "Calibre xRC"
* Version "v2017.2_16.14"
*
.subckt BPD24D VSS PAD TO_CORE P_EN VDD N_EN
M0 VDD 3 4 VDD P L=3e-06 W=3.5e-05 AD=1.5985e-10 AS=1.295e-10 PD=8.18e-05
+ PS=7.74e-05 NRD=0.0688095 NRS=0.0557143
M1 TO_CORE 4 VDD VDD P L=1.5e-06 W=3.65e-05 AD=1.4235e-10 AS=1.5985e-10
+ PD=8.08e-05 PS=8.18e-05 NRD=0.0534247 NRS=0.0534247
M2 VDD 4 TO_CORE VDD P L=1.5e-06 W=3.65e-05 AD=1.3505e-10 AS=1.4235e-10
+ PD=8.04e-05 PS=8.08e-05 NRD=0.0534247 NRS=0.0534247
M3 VDD P_EN PAD VDD P L=1.8e-06 W=6.5e-05 AD=2.535e-10 AS=2.405e-10 PD=0.0001378
+ PS=0.0001374 NRD=0.03 NRS=0.03
M4 PAD P_EN VDD VDD P L=1.8e-06 W=6.5e-05 AD=2.535e-10 AS=2.535e-10 PD=0.0001378
+ PS=0.0001378 NRD=0.03 NRS=0.03
M5 VDD P_EN PAD VDD P L=1.8e-06 W=6.5e-05 AD=2.535e-10 AS=2.535e-10 PD=0.0001378
+ PS=0.0001378 NRD=0.03 NRS=0.03
M6 PAD P_EN VDD VDD P L=1.8e-06 W=6.5e-05 AD=2.735e-10 AS=2.535e-10 PD=0.0001388
+ PS=0.0001378 NRD=0.03 NRS=0.03
M7 VDD P_EN PAD VDD P L=1.8e-06 W=4e-05 AD=1.48e-10 AS=2.735e-10 PD=8.74e-05
+ PS=0.0001388 NRD=0.04875 NRS=0.06125
M8 VSS 3 4 VSS N L=3e-06 W=1.9e-05 AD=1.9515e-10 AS=7.03e-11 PD=0.0001029
+ PS=4.54e-05 NRD=0.128947 NRS=0.102632
M9 TO_CORE 4 VSS VSS N L=1.2e-06 W=4.7e-05 AD=1.739e-10 AS=1.9515e-10
+ PD=0.0001014 PS=0.0001029 NRD=0.0414894 NRS=0.0425532
M10 VSS N_EN PAD VSS N L=1.5e-06 W=6.675e-05 AD=2.60325e-10 AS=2.46975e-10
+ PD=0.0001413 PS=0.0001409 NRD=0.0292135 NRS=0.0292135
M11 PAD N_EN VSS VSS N L=1.5e-06 W=6.675e-05 AD=2.60325e-10 AS=2.60325e-10
+ PD=0.0001413 PS=0.0001413 NRD=0.0292135 NRS=0.0292135
M12 VSS N_EN PAD VSS N L=1.5e-06 W=6.675e-05 AD=3.23515e-10 AS=2.60325e-10
+ PD=0.0001697 PS=0.0001413 NRD=0.0328756 NRS=0.0292135
M13 PAD N_EN VSS VSS N L=1.5e-06 W=7.5e-05 AD=2.77902e-10 AS=3.23515e-10
+ PD=0.0001507 PS=0.0001697 NRD=0.0290667 NRS=0.0276358
M14 VSS VDD PAD VSS N L=7e-06 W=2.5e-06 AD=1.35e-11 AS=2.77902e-10 PD=1.5e-05
+ PS=0.0001507 NRD=0.3 NRS=0.885366
*R15 PAD 3 686.333
XR0 PAD 3 RNW W=45u L=14.5u
D16 VSS PAD DNWELLPSUB  AREA=0.207105
D17 PAD VDD DPDIFFNWELL  AREA=0.0104896
D18 3 VDD DPDIFFNWELL  AREA=0.00302336
D19 VSS 3 DNDIFFPSUB  AREA=0.0154093
.ends
*
*
* File: BPD24U.sp
* Created: Wed Apr 29 12:58:33 2026
* Program "Calibre xRC"
* Version "v2017.2_16.14"
*
.subckt BPD24U VSS PAD TO_CORE P_EN N_EN VDD
M0 VDD 3 4 VDD P L=3e-06 W=3.4e-05 AD=1.5935e-10 AS=1.258e-10 PD=8.18e-05
+ PS=7.54e-05 NRD=0.0720588 NRS=0.0573529
M1 PAD VSS VDD VDD P L=3e-06 W=2.5e-06 AD=1.04735e-10 AS=1.5375e-11 PD=4.35e-05
+ PS=1.65e-05 NRD=0.3 NRS=0.518182
M2 TO_CORE 4 VDD VDD P L=1.5e-06 W=3.65e-05 AD=1.4235e-10 AS=1.5935e-10
+ PD=8.08e-05 PS=8.18e-05 NRD=0.0534247 NRS=0.0534247
M3 VDD 4 TO_CORE VDD P L=1.5e-06 W=3.65e-05 AD=1.3505e-10 AS=1.4235e-10
+ PD=8.04e-05 PS=8.08e-05 NRD=0.0534247 NRS=0.0534247
M4 VDD P_EN PAD VDD P L=1.8e-06 W=6.5e-05 AD=2.535e-10 AS=2.405e-10 PD=0.0001378
+ PS=0.0001374 NRD=0.03 NRS=0.03
M5 PAD P_EN VDD VDD P L=1.8e-06 W=6.5e-05 AD=2.535e-10 AS=2.535e-10 PD=0.0001378
+ PS=0.0001378 NRD=0.03 NRS=0.03
M6 VDD P_EN PAD VDD P L=1.8e-06 W=6.5e-05 AD=2.535e-10 AS=2.535e-10 PD=0.0001378
+ PS=0.0001378 NRD=0.03 NRS=0.03
M7 PAD P_EN VDD VDD P L=1.8e-06 W=6.5e-05 AD=2.735e-10 AS=2.535e-10 PD=0.0001388
+ PS=0.0001378 NRD=0.03 NRS=0.03
M8 VDD P_EN PAD VDD P L=1.8e-06 W=4e-05 AD=1.48e-10 AS=2.735e-10 PD=8.74e-05
+ PS=0.0001388 NRD=0.04875 NRS=0.06125
M9 VSS 3 4 VSS N L=3e-06 W=1.5e-05 AD=1.7735e-10 AS=5.55e-11 PD=9.49e-05
+ PS=3.74e-05 NRD=0.163333 NRS=0.13
M10 TO_CORE 4 VSS VSS N L=1.2e-06 W=4.3e-05 AD=1.591e-10 AS=1.7735e-10
+ PD=9.34e-05 PS=9.49e-05 NRD=0.0453488 NRS=0.0465116
M11 VSS N_EN PAD VSS N L=1.5e-06 W=6.665e-05 AD=2.59935e-10 AS=2.46605e-10
+ PD=0.0001411 PS=0.0001407 NRD=0.0292573 NRS=0.0292573
M12 PAD N_EN VSS VSS N L=1.5e-06 W=6.665e-05 AD=2.59935e-10 AS=2.59935e-10
+ PD=0.0001411 PS=0.0001411 NRD=0.0292573 NRS=0.0292573
M13 VSS N_EN PAD VSS N L=1.5e-06 W=6.665e-05 AD=3.21705e-10 AS=2.59935e-10
+ PD=0.0001695 PS=0.0001411 NRD=0.0329249 NRS=0.0292573
M14 PAD N_EN VSS VSS N L=1.5e-06 W=7.5e-05 AD=2.83867e-10 AS=3.21705e-10
+ PD=0.000147 PS=0.0001695 NRD=0.0262807 NRS=0.0276358
*R15 PAD 3 686.333
XR0 PAD 3 RNW W=45u L=14.5u
D16 VSS PAD DNWELLPSUB  AREA=0.207105
D17 PAD VDD DPDIFFNWELL  AREA=0.0104896
D18 3 VDD DPDIFFNWELL  AREA=0.00302336
D19 VSS 3 DNDIFFPSUB  AREA=0.0154093
.ends
*
*
* File: BPD320.sp
* Created: Wed Apr 29 12:58:35 2026
* Program "Calibre xRC"
* Version "v2017.2_16.14"
*
.subckt BPD320 VSS PAD P_EN N_EN VDD TO_CORE
M0 VDD P_EN PAD VDD P L=1.8e-06 W=8.7e-05 AD=3.393e-10 AS=3.306e-10 PD=0.0001818
+ PS=0.0001816 NRD=0.0224138 NRS=0.0235632
M1 PAD P_EN VDD VDD P L=1.8e-06 W=8.7e-05 AD=3.393e-10 AS=3.393e-10 PD=0.0001818
+ PS=0.0001818 NRD=0.0224138 NRS=0.0224138
M2 VDD P_EN PAD VDD P L=1.8e-06 W=8.7e-05 AD=3.219e-10 AS=3.393e-10 PD=0.0001814
+ PS=0.0001818 NRD=0.0224138 NRS=0.0224138
M3 TO_CORE 10 VDD VDD P L=1.5e-06 W=2e-05 AD=7.8e-11 AS=7.4e-11 PD=4.78e-05
+ PS=4.74e-05 NRD=0.0975 NRS=0.0975
M4 TO_CORE 10 VDD VDD P L=1.5e-06 W=2e-05 AD=7.8e-11 AS=7.8e-11 PD=4.78e-05
+ PS=4.78e-05 NRD=0.0975 NRS=0.0975
M5 TO_CORE 10 VDD VDD P L=1.5e-06 W=2e-05 AD=7.4e-11 AS=7.8e-11 PD=4.74e-05
+ PS=4.78e-05 NRD=0.0975 NRS=0.0975
M6 8 3 VDD VDD P L=2.5e-06 W=1.5e-05 AD=5.85e-11 AS=5.55e-11 PD=3.78e-05
+ PS=3.74e-05 NRD=0.13 NRS=0.13
M7 VDD 3 8 VDD P L=2.5e-06 W=1.5e-05 AD=5.85e-11 AS=5.85e-11 PD=3.78e-05
+ PS=3.78e-05 NRD=0.13 NRS=0.13
M8 VDD 3 8 VDD P L=2.5e-06 W=1.5e-05 AD=5.85e-11 AS=5.85e-11 PD=3.78e-05
+ PS=3.78e-05 NRD=0.13 NRS=0.13
M9 VSS 10 8 VDD P L=2.5e-06 W=1.5e-05 AD=5.85e-11 AS=5.85e-11 PD=3.78e-05
+ PS=3.78e-05 NRD=0.13 NRS=0.13
M10 VSS 10 8 VDD P L=2.5e-06 W=1.5e-05 AD=5.85e-11 AS=5.85e-11 PD=3.78e-05
+ PS=3.78e-05 NRD=0.13 NRS=0.13
M11 VSS 10 8 VDD P L=2.5e-06 W=1.5e-05 AD=5.85e-11 AS=5.85e-11 PD=3.78e-05
+ PS=3.78e-05 NRD=0.13 NRS=0.13
M12 VSS 10 8 VDD P L=2.5e-06 W=1.5e-05 AD=5.85e-11 AS=5.85e-11 PD=3.78e-05
+ PS=3.78e-05 NRD=0.13 NRS=0.13
M13 VSS 10 8 VDD P L=2.5e-06 W=1.5e-05 AD=5.85e-11 AS=5.85e-11 PD=3.78e-05
+ PS=3.78e-05 NRD=0.13 NRS=0.13
M14 VSS 10 8 VDD P L=2.5e-06 W=1.5e-05 AD=5.85e-11 AS=8.15e-11 PD=3.78e-05
+ PS=4.84e-05 NRD=0.13 NRS=0.15
M15 10 3 8 VDD P L=2.5e-06 W=2e-05 AD=7.8e-11 AS=8.15e-11 PD=4.78e-05
+ PS=4.84e-05 NRD=0.0975 NRS=0.0975
M16 10 3 8 VDD P L=2.5e-06 W=2e-05 AD=7.8e-11 AS=7.8e-11 PD=4.78e-05 PS=4.78e-05
+ NRD=0.0975 NRS=0.0975
M17 10 3 8 VDD P L=2.5e-06 W=2e-05 AD=7.8e-11 AS=7.8e-11 PD=4.78e-05 PS=4.78e-05
+ NRD=0.0975 NRS=0.0975
M18 10 3 8 VDD P L=2.5e-06 W=2e-05 AD=7.8e-11 AS=7.4e-11 PD=4.78e-05 PS=4.74e-05
+ NRD=0.0975 NRS=0.0975
M19 VSS N_EN PAD VSS N L=1.5e-06 W=6.7e-05 AD=4.623e-10 AS=4.489e-10
+ PD=0.0001478 PS=0.0001474 NRD=0.0392809 NRS=0.0291045
M20 PAD N_EN VSS VSS N L=1.5e-06 W=6.7e-05 AD=5.025e-10 AS=4.623e-10 PD=0.000149
+ PS=0.0001478 NRD=0.040652 NRS=0.0392809
M21 VSS N_EN PAD VSS N L=1.5e-06 W=6.7e-05 AD=2.479e-10 AS=5.025e-10
+ PD=0.0001414 PS=0.000149 NRD=0.0291045 NRS=0.040652
M22 VSS 10 TO_CORE VSS N L=1.2e-06 W=1.75e-05 AD=6.825e-11 AS=6.475e-11
+ PD=4.28e-05 PS=4.24e-05 NRD=0.111429 NRS=0.111429
M23 VSS 10 TO_CORE VSS N L=1.2e-06 W=1.75e-05 AD=6.825e-11 AS=6.475e-11
+ PD=4.28e-05 PS=4.24e-05 NRD=0.111429 NRS=0.111429
M24 10 3 7 VSS N L=2e-06 W=2e-05 AD=7.8e-11 AS=7.4e-11 PD=4.78e-05 PS=4.74e-05
+ NRD=0.0975 NRS=0.0975
M25 10 3 7 VSS N L=2e-06 W=2e-05 AD=7.8e-11 AS=8.275e-11 PD=4.78e-05 PS=4.84e-05
+ NRD=0.0975 NRS=0.0975
M26 7 10 VDD VSS N L=2e-06 W=1.75e-05 AD=8.275e-11 AS=6.825e-11 PD=4.84e-05
+ PS=4.28e-05 NRD=0.122857 NRS=0.111429
M27 7 10 VDD VSS N L=2e-06 W=1.75e-05 AD=1.1975e-10 AS=6.825e-11 PD=6.84e-05
+ PS=4.28e-05 NRD=0.122857 NRS=0.111429
M28 VSS 3 7 VSS N L=2e-06 W=3e-05 AD=1.12242e-10 AS=1.1975e-10 PD=6.74e-05
+ PS=6.84e-05 NRD=0.0887037 NRS=0.0704167
*R29 PAD 3 686.333
XR0 PAD 3 RNW W=45u L=14.5u
D30 VSS PAD DNWELLPSUB  AREA=0.207105
D31 PAD VDD DPDIFFNWELL  AREA=0.0104896
D32 3 VDD DPDIFFNWELL  AREA=0.00302336
D33 VSS 3 DNDIFFPSUB  AREA=0.0154093
.ends
*
*
* File: BPD340.sp
* Created: Wed Apr 29 12:58:37 2026
* Program "Calibre xRC"
* Version "v2017.2_16.14"
*
.subckt BPD340 VSS PAD P_EN N_EN VDD TO_CORE
M0 VDD P_EN PAD VDD P L=1.8e-06 W=8.15e-05 AD=3.1785e-10 AS=3.097e-10
+ PD=0.0001708 PS=0.0001706 NRD=0.0239264 NRS=0.0251534
M1 PAD P_EN VDD VDD P L=1.8e-06 W=8.15e-05 AD=3.1785e-10 AS=3.1785e-10
+ PD=0.0001708 PS=0.0001708 NRD=0.0239264 NRS=0.0239264
M2 VDD P_EN PAD VDD P L=1.8e-06 W=8.15e-05 AD=5.738e-10 AS=3.1785e-10
+ PD=0.0001774 PS=0.0001708 NRD=0.0239264 NRS=0.0239264
M3 PAD P_EN VDD VDD P L=1.8e-06 W=5.55e-05 AD=3.7185e-10 AS=5.738e-10
+ PD=0.0001244 PS=0.0001774 NRD=0.0351351 NRS=0.04004
M4 TO_CORE 10 VDD VDD P L=1.5e-06 W=2e-05 AD=7.8e-11 AS=7.4e-11 PD=4.78e-05
+ PS=4.74e-05 NRD=0.0975 NRS=0.0975
M5 TO_CORE 10 VDD VDD P L=1.5e-06 W=2e-05 AD=7.8e-11 AS=7.8e-11 PD=4.78e-05
+ PS=4.78e-05 NRD=0.0975 NRS=0.0975
M6 TO_CORE 10 VDD VDD P L=1.5e-06 W=2e-05 AD=7.4e-11 AS=7.8e-11 PD=4.74e-05
+ PS=4.78e-05 NRD=0.0975 NRS=0.0975
M7 8 3 VDD VDD P L=2.5e-06 W=1.5e-05 AD=5.85e-11 AS=5.55e-11 PD=3.78e-05
+ PS=3.74e-05 NRD=0.13 NRS=0.13
M8 VDD 3 8 VDD P L=2.5e-06 W=1.5e-05 AD=5.85e-11 AS=5.85e-11 PD=3.78e-05
+ PS=3.78e-05 NRD=0.13 NRS=0.13
M9 VDD 3 8 VDD P L=2.5e-06 W=1.5e-05 AD=5.85e-11 AS=5.85e-11 PD=3.78e-05
+ PS=3.78e-05 NRD=0.13 NRS=0.13
M10 VSS 10 8 VDD P L=2.5e-06 W=1.5e-05 AD=5.85e-11 AS=5.85e-11 PD=3.78e-05
+ PS=3.78e-05 NRD=0.13 NRS=0.13
M11 VSS 10 8 VDD P L=2.5e-06 W=1.5e-05 AD=5.85e-11 AS=5.85e-11 PD=3.78e-05
+ PS=3.78e-05 NRD=0.13 NRS=0.13
M12 VSS 10 8 VDD P L=2.5e-06 W=1.5e-05 AD=5.85e-11 AS=5.85e-11 PD=3.78e-05
+ PS=3.78e-05 NRD=0.13 NRS=0.13
M13 VSS 10 8 VDD P L=2.5e-06 W=1.5e-05 AD=5.85e-11 AS=5.85e-11 PD=3.78e-05
+ PS=3.78e-05 NRD=0.13 NRS=0.13
M14 VSS 10 8 VDD P L=2.5e-06 W=1.5e-05 AD=5.85e-11 AS=5.85e-11 PD=3.78e-05
+ PS=3.78e-05 NRD=0.13 NRS=0.13
M15 VSS 10 8 VDD P L=2.5e-06 W=1.5e-05 AD=5.85e-11 AS=8.15e-11 PD=3.78e-05
+ PS=4.84e-05 NRD=0.13 NRS=0.15
M16 10 3 8 VDD P L=2.5e-06 W=2e-05 AD=7.8e-11 AS=8.15e-11 PD=4.78e-05
+ PS=4.84e-05 NRD=0.0975 NRS=0.0975
M17 10 3 8 VDD P L=2.5e-06 W=2e-05 AD=7.8e-11 AS=7.8e-11 PD=4.78e-05 PS=4.78e-05
+ NRD=0.0975 NRS=0.0975
M18 10 3 8 VDD P L=2.5e-06 W=2e-05 AD=7.8e-11 AS=7.8e-11 PD=4.78e-05 PS=4.78e-05
+ NRD=0.0975 NRS=0.0975
M19 10 3 8 VDD P L=2.5e-06 W=2e-05 AD=7.8e-11 AS=7.4e-11 PD=4.78e-05 PS=4.74e-05
+ NRD=0.0975 NRS=0.0975
M20 VSS N_EN PAD VSS N L=1.5e-06 W=6.9e-05 AD=4.761e-10 AS=4.623e-10
+ PD=0.0001518 PS=0.0001514 NRD=0.036166 NRS=0.0282609
M21 PAD N_EN VSS VSS N L=1.5e-06 W=6.9e-05 AD=4.968e-10 AS=4.761e-10
+ PD=0.0001524 PS=0.0001518 NRD=0.0394737 NRS=0.0381423
M22 VSS N_EN PAD VSS N L=1.5e-06 W=6.9e-05 AD=4.761e-10 AS=4.968e-10
+ PD=0.0001518 PS=0.0001524 NRD=0.0381423 NRS=0.0374142
M23 PAD N_EN VSS VSS N L=1.5e-06 W=6.9e-05 AD=4.623e-10 AS=4.761e-10
+ PD=0.0001514 PS=0.0001518 NRD=0.0282609 NRS=0.0381423
M24 VSS 10 TO_CORE VSS N L=1.2e-06 W=1.75e-05 AD=6.825e-11 AS=6.475e-11
+ PD=4.28e-05 PS=4.24e-05 NRD=0.111429 NRS=0.111429
M25 VSS 10 TO_CORE VSS N L=1.2e-06 W=1.75e-05 AD=6.825e-11 AS=6.475e-11
+ PD=4.28e-05 PS=4.24e-05 NRD=0.111429 NRS=0.111429
M26 10 3 7 VSS N L=2e-06 W=2e-05 AD=7.8e-11 AS=7.4e-11 PD=4.78e-05 PS=4.74e-05
+ NRD=0.0975 NRS=0.0975
M27 10 3 7 VSS N L=2e-06 W=2e-05 AD=7.8e-11 AS=8.275e-11 PD=4.78e-05 PS=4.84e-05
+ NRD=0.0975 NRS=0.0975
M28 7 10 VDD VSS N L=2e-06 W=1.75e-05 AD=8.275e-11 AS=6.825e-11 PD=4.84e-05
+ PS=4.28e-05 NRD=0.122857 NRS=0.111429
M29 7 10 VDD VSS N L=2e-06 W=1.75e-05 AD=1.1975e-10 AS=6.825e-11 PD=6.84e-05
+ PS=4.28e-05 NRD=0.122857 NRS=0.111429
M30 VSS 3 7 VSS N L=2e-06 W=3e-05 AD=1.12242e-10 AS=1.1975e-10 PD=6.74e-05
+ PS=6.84e-05 NRD=0.0887037 NRS=0.0704167
*R31 PAD 3 686.333
XR0 PAD 3 RNW W=45u L=14.5u
D32 VSS PAD DNWELLPSUB  AREA=0.207105
D33 PAD VDD DPDIFFNWELL  AREA=0.0104896
D34 3 VDD DPDIFFNWELL  AREA=0.00302336
D35 VSS 3 DNDIFFPSUB  AREA=0.0154093
.ends
*
*

* File: IPAD20.sp
* Created: Mon Apr 27 16:24:37 2026
* Program "Calibre xRC"
* Version "v2017.2_16.14"
*
.subckt IPAD20 VSS IN1 OUT1 VDD
M0 VDD 3 4 VDD P L=3e-06 W=3.4e-05 AD=1.5935e-10 AS=1.258e-10 PD=8.18e-05
+ PS=7.54e-05 NRD=0.0720588 NRS=0.0573529
M1 OUT1 4 VDD VDD P L=1.5e-06 W=3.65e-05 AD=1.4235e-10 AS=1.5935e-10 PD=8.08e-05
+ PS=8.18e-05 NRD=0.0534247 NRS=0.0534247
M2 VDD 4 OUT1 VDD P L=1.5e-06 W=3.65e-05 AD=1.3505e-10 AS=1.4235e-10 PD=8.04e-05
+ PS=8.08e-05 NRD=0.0534247 NRS=0.0534247
M3 VSS 3 4 VSS N L=3e-06 W=1.7e-05 AD=1.7835e-10 AS=6.29e-11 PD=9.49e-05
+ PS=4.14e-05 NRD=0.139216 NRS=0.114706
M4 OUT1 4 VSS VSS N L=1.2e-06 W=4.3e-05 AD=1.591e-10 AS=1.7835e-10 PD=9.34e-05
+ PS=9.49e-05 NRD=0.0453488 NRS=0.0465116
*R5 IN1 3 686.333
XR0 IN1 3 RNW W=45u L=14.5u
D6 VSS IN1 DNWELLPSUB  AREA=0.207105
D7 IN1 VDD DPDIFFNWELL  AREA=0.0104896
D8 3 VDD DPDIFFNWELL  AREA=0.00302336
D9 VSS 3 DNDIFFPSUB  AREA=0.0154093
.ends
*
*
* File: IPAD2D.sp
* Created: Wed Apr 29 12:58:11 2026
* Program "Calibre xRC"
* Version "v2017.2_16.14"
*
.subckt IPAD2D VSS IN1 VDD OUT1
M0 VDD 3 5 VDD P L=3e-06 W=3.5e-05 AD=1.5985e-10 AS=1.295e-10 PD=8.18e-05
+ PS=7.74e-05 NRD=0.0688095 NRS=0.0557143
M1 OUT1 5 VDD VDD P L=1.5e-06 W=3.65e-05 AD=1.4235e-10 AS=1.5985e-10 PD=8.08e-05
+ PS=8.18e-05 NRD=0.0534247 NRS=0.0534247
M2 VDD 5 OUT1 VDD P L=1.5e-06 W=3.65e-05 AD=1.3505e-10 AS=1.4235e-10 PD=8.04e-05
+ PS=8.08e-05 NRD=0.0534247 NRS=0.0534247
M3 VSS 3 5 VSS N L=3e-06 W=1.9e-05 AD=1.9515e-10 AS=7.03e-11 PD=0.0001029
+ PS=4.54e-05 NRD=0.125188 NRS=0.102632
M4 VSS VDD IN1 VSS N L=7e-06 W=2.5e-06 AD=1.35e-11 AS=1.10525e-10 PD=1.5e-05
+ PS=4.61e-05 NRD=0.7 NRS=1.14706
M5 OUT1 5 VSS VSS N L=1.2e-06 W=4.7e-05 AD=1.739e-10 AS=1.9515e-10 PD=0.0001014
+ PS=0.0001029 NRD=0.0414894 NRS=0.0425532
*R6 IN1 3 686.333
XR0 IN1 3 RNW W=45u L=14.5u
D7 VSS IN1 DNWELLPSUB  AREA=0.207105
D8 IN1 VDD DPDIFFNWELL  AREA=0.0104896
D9 3 VDD DPDIFFNWELL  AREA=0.00302336
D10 VSS 3 DNDIFFPSUB  AREA=0.0154093
.ends
*
*
* File: IPAD2U.sp
* Created: Wed Apr 29 12:58:13 2026
* Program "Calibre xRC"
* Version "v2017.2_16.14"
*
.subckt IPAD2U VSS IN1 OUT1 VDD
M0 VDD 3 4 VDD P L=3e-06 W=3.4e-05 AD=1.5935e-10 AS=1.258e-10 PD=8.18e-05
+ PS=7.54e-05 NRD=0.0720588 NRS=0.0573529
M1 IN1 VSS VDD VDD P L=3e-06 W=2.5e-06 AD=1.2244e-10 AS=1.5375e-11 PD=4.93e-05
+ PS=1.65e-05 NRD=0.3 NRS=0.518182
M2 OUT1 4 VDD VDD P L=1.5e-06 W=3.65e-05 AD=1.4235e-10 AS=1.5935e-10 PD=8.08e-05
+ PS=8.18e-05 NRD=0.0534247 NRS=0.0534247
M3 VDD 4 OUT1 VDD P L=1.5e-06 W=3.65e-05 AD=1.3505e-10 AS=1.4235e-10 PD=8.04e-05
+ PS=8.08e-05 NRD=0.0534247 NRS=0.0534247
M4 VSS 3 4 VSS N L=3e-06 W=1.5e-05 AD=1.7735e-10 AS=5.55e-11 PD=9.49e-05
+ PS=3.74e-05 NRD=0.163333 NRS=0.13
M5 OUT1 4 VSS VSS N L=1.2e-06 W=4.3e-05 AD=1.591e-10 AS=1.7735e-10 PD=9.34e-05
+ PS=9.49e-05 NRD=0.0453488 NRS=0.0465116
*R6 IN1 3 686.333
XR0 IN1 3 RNW W=45u L=14.5u
D7 VSS IN1 DNWELLPSUB  AREA=0.207105
D8 IN1 VDD DPDIFFNWELL  AREA=0.0104896
D9 3 VDD DPDIFFNWELL  AREA=0.00302336
D10 VSS 3 DNDIFFPSUB  AREA=0.0154093
.ends
*
*
* File: IPAD30.sp
* Created: Wed Apr 29 12:58:14 2026
* Program "Calibre xRC"
* Version "v2017.2_16.14"
*
.subckt IPAD30 VSS IN1 VDD OUT1
M0 OUT1 8 VDD VDD P L=1.5e-06 W=2e-05 AD=7.8e-11 AS=7.4e-11 PD=4.78e-05
+ PS=4.74e-05 NRD=0.0975 NRS=0.0975
M1 OUT1 8 VDD VDD P L=1.5e-06 W=2e-05 AD=7.8e-11 AS=7.8e-11 PD=4.78e-05
+ PS=4.78e-05 NRD=0.0975 NRS=0.0975
M2 OUT1 8 VDD VDD P L=1.5e-06 W=2e-05 AD=7.4e-11 AS=7.8e-11 PD=4.74e-05
+ PS=4.78e-05 NRD=0.0975 NRS=0.0975
M3 6 3 VDD VDD P L=2.5e-06 W=1.5e-05 AD=5.85e-11 AS=5.55e-11 PD=3.78e-05
+ PS=3.74e-05 NRD=0.13 NRS=0.13
M4 VDD 3 6 VDD P L=2.5e-06 W=1.5e-05 AD=5.85e-11 AS=5.85e-11 PD=3.78e-05
+ PS=3.78e-05 NRD=0.13 NRS=0.13
M5 VDD 3 6 VDD P L=2.5e-06 W=1.5e-05 AD=5.85e-11 AS=5.85e-11 PD=3.78e-05
+ PS=3.78e-05 NRD=0.13 NRS=0.13
M6 VSS 8 6 VDD P L=2.5e-06 W=1.5e-05 AD=5.85e-11 AS=5.85e-11 PD=3.78e-05
+ PS=3.78e-05 NRD=0.13 NRS=0.13
M7 VSS 8 6 VDD P L=2.5e-06 W=1.5e-05 AD=5.85e-11 AS=5.85e-11 PD=3.78e-05
+ PS=3.78e-05 NRD=0.13 NRS=0.13
M8 VSS 8 6 VDD P L=2.5e-06 W=1.5e-05 AD=5.85e-11 AS=5.85e-11 PD=3.78e-05
+ PS=3.78e-05 NRD=0.13 NRS=0.13
M9 VSS 8 6 VDD P L=2.5e-06 W=1.5e-05 AD=5.85e-11 AS=5.85e-11 PD=3.78e-05
+ PS=3.78e-05 NRD=0.13 NRS=0.13
M10 VSS 8 6 VDD P L=2.5e-06 W=1.5e-05 AD=5.85e-11 AS=5.85e-11 PD=3.78e-05
+ PS=3.78e-05 NRD=0.13 NRS=0.13
M11 VSS 8 6 VDD P L=2.5e-06 W=1.5e-05 AD=5.85e-11 AS=8.15e-11 PD=3.78e-05
+ PS=4.84e-05 NRD=0.13 NRS=0.15
M12 8 3 6 VDD P L=2.5e-06 W=2e-05 AD=7.8e-11 AS=8.15e-11 PD=4.78e-05 PS=4.84e-05
+ NRD=0.0975 NRS=0.0975
M13 8 3 6 VDD P L=2.5e-06 W=2e-05 AD=7.8e-11 AS=7.8e-11 PD=4.78e-05 PS=4.78e-05
+ NRD=0.0975 NRS=0.0975
M14 8 3 6 VDD P L=2.5e-06 W=2e-05 AD=7.8e-11 AS=7.8e-11 PD=4.78e-05 PS=4.78e-05
+ NRD=0.0975 NRS=0.0975
M15 8 3 6 VDD P L=2.5e-06 W=2e-05 AD=7.8e-11 AS=7.4e-11 PD=4.78e-05 PS=4.74e-05
+ NRD=0.0975 NRS=0.0975
M16 VSS 8 OUT1 VSS N L=1.2e-06 W=1.75e-05 AD=6.825e-11 AS=6.475e-11 PD=4.28e-05
+ PS=4.24e-05 NRD=0.111429 NRS=0.111429
M17 VSS 8 OUT1 VSS N L=1.2e-06 W=1.75e-05 AD=6.825e-11 AS=6.475e-11 PD=4.28e-05
+ PS=4.24e-05 NRD=0.111429 NRS=0.111429
M18 8 3 5 VSS N L=2e-06 W=2e-05 AD=7.8e-11 AS=7.4e-11 PD=4.78e-05 PS=4.74e-05
+ NRD=0.0975 NRS=0.0975
M19 8 3 5 VSS N L=2e-06 W=2e-05 AD=7.8e-11 AS=8.275e-11 PD=4.78e-05 PS=4.84e-05
+ NRD=0.0975 NRS=0.0975
M20 5 8 VDD VSS N L=2e-06 W=1.75e-05 AD=8.275e-11 AS=6.825e-11 PD=4.84e-05
+ PS=4.28e-05 NRD=0.122857 NRS=0.111429
M21 5 8 VDD VSS N L=2e-06 W=1.75e-05 AD=1.234e-10 AS=6.825e-11 PD=6.94e-05
+ PS=4.28e-05 NRD=0.128571 NRS=0.111429
M22 5 3 VSS VSS N L=2e-06 W=3e-05 AD=1.234e-10 AS=1.24715e-10 PD=6.94e-05
+ PS=6.05e-05 NRD=0.0862963 NRS=0.0737226
*R23 IN1 3 686.333
XR0 IN1 3 RNW W=45u L=14.5u
D24 VSS IN1 DNWELLPSUB  AREA=0.207105
D25 IN1 VDD DPDIFFNWELL  AREA=0.0104896
D26 3 VDD DPDIFFNWELL  AREA=0.00302336
D27 VSS 3 DNDIFFPSUB  AREA=0.0154093
.ends
*
*
* File: IPAD3D.sp
* Created: Wed Apr 29 12:58:16 2026
* Program "Calibre xRC"
* Version "v2017.2_16.14"
*
.subckt IPAD3D VSS IN1 VDD OUT1
M0 OUT1 8 VDD VDD P L=1.5e-06 W=2e-05 AD=7.8e-11 AS=7.4e-11 PD=4.78e-05
+ PS=4.74e-05 NRD=0.0975 NRS=0.0975
M1 OUT1 8 VDD VDD P L=1.5e-06 W=2e-05 AD=7.8e-11 AS=7.8e-11 PD=4.78e-05
+ PS=4.78e-05 NRD=0.0975 NRS=0.0975
M2 OUT1 8 VDD VDD P L=1.5e-06 W=2e-05 AD=7.4e-11 AS=7.8e-11 PD=4.74e-05
+ PS=4.78e-05 NRD=0.0975 NRS=0.0975
M3 6 3 VDD VDD P L=2.5e-06 W=1.5e-05 AD=5.85e-11 AS=5.55e-11 PD=3.78e-05
+ PS=3.74e-05 NRD=0.13 NRS=0.13
M4 VDD 3 6 VDD P L=2.5e-06 W=1.5e-05 AD=5.85e-11 AS=5.85e-11 PD=3.78e-05
+ PS=3.78e-05 NRD=0.13 NRS=0.13
M5 VDD 3 6 VDD P L=2.5e-06 W=1.5e-05 AD=5.85e-11 AS=5.85e-11 PD=3.78e-05
+ PS=3.78e-05 NRD=0.13 NRS=0.13
M6 VSS 8 6 VDD P L=2.5e-06 W=1.5e-05 AD=5.85e-11 AS=5.85e-11 PD=3.78e-05
+ PS=3.78e-05 NRD=0.13 NRS=0.13
M7 VSS 8 6 VDD P L=2.5e-06 W=1.5e-05 AD=5.85e-11 AS=5.85e-11 PD=3.78e-05
+ PS=3.78e-05 NRD=0.13 NRS=0.13
M8 VSS 8 6 VDD P L=2.5e-06 W=1.5e-05 AD=5.85e-11 AS=5.85e-11 PD=3.78e-05
+ PS=3.78e-05 NRD=0.13 NRS=0.13
M9 VSS 8 6 VDD P L=2.5e-06 W=1.5e-05 AD=5.85e-11 AS=5.85e-11 PD=3.78e-05
+ PS=3.78e-05 NRD=0.13 NRS=0.13
M10 VSS 8 6 VDD P L=2.5e-06 W=1.5e-05 AD=5.85e-11 AS=5.85e-11 PD=3.78e-05
+ PS=3.78e-05 NRD=0.13 NRS=0.13
M11 VSS 8 6 VDD P L=2.5e-06 W=1.5e-05 AD=5.85e-11 AS=8.15e-11 PD=3.78e-05
+ PS=4.84e-05 NRD=0.13 NRS=0.15
M12 8 3 6 VDD P L=2.5e-06 W=2e-05 AD=7.8e-11 AS=8.15e-11 PD=4.78e-05 PS=4.84e-05
+ NRD=0.0975 NRS=0.0975
M13 8 3 6 VDD P L=2.5e-06 W=2e-05 AD=7.8e-11 AS=7.8e-11 PD=4.78e-05 PS=4.78e-05
+ NRD=0.0975 NRS=0.0975
M14 8 3 6 VDD P L=2.5e-06 W=2e-05 AD=7.8e-11 AS=7.8e-11 PD=4.78e-05 PS=4.78e-05
+ NRD=0.0975 NRS=0.0975
M15 8 3 6 VDD P L=2.5e-06 W=2e-05 AD=7.8e-11 AS=7.4e-11 PD=4.78e-05 PS=4.74e-05
+ NRD=0.0975 NRS=0.0975
M16 IN1 VDD VSS VSS N L=7e-06 W=2.5e-06 AD=3.4325e-11 AS=1.8645e-11 PD=2.43e-05
+ PS=1.79e-05 NRD=0.9 NRS=0.9
M17 VSS 8 OUT1 VSS N L=1.2e-06 W=1.75e-05 AD=6.825e-11 AS=6.475e-11 PD=4.28e-05
+ PS=4.24e-05 NRD=0.111429 NRS=0.111429
M18 VSS 8 OUT1 VSS N L=1.2e-06 W=1.75e-05 AD=6.825e-11 AS=6.475e-11 PD=4.28e-05
+ PS=4.24e-05 NRD=0.111429 NRS=0.111429
M19 8 3 5 VSS N L=2e-06 W=2e-05 AD=7.8e-11 AS=7.4e-11 PD=4.78e-05 PS=4.74e-05
+ NRD=0.0975 NRS=0.0975
M20 8 3 5 VSS N L=2e-06 W=2e-05 AD=7.8e-11 AS=8.275e-11 PD=4.78e-05 PS=4.84e-05
+ NRD=0.0975 NRS=0.0975
M21 5 8 VDD VSS N L=2e-06 W=1.75e-05 AD=8.275e-11 AS=6.825e-11 PD=4.84e-05
+ PS=4.28e-05 NRD=0.122857 NRS=0.111429
M22 5 8 VDD VSS N L=2e-06 W=1.75e-05 AD=1.234e-10 AS=6.825e-11 PD=6.94e-05
+ PS=4.28e-05 NRD=0.128571 NRS=0.111429
M23 5 3 VSS VSS N L=2e-06 W=3e-05 AD=1.234e-10 AS=1.24715e-10 PD=6.94e-05
+ PS=6.05e-05 NRD=0.0862963 NRS=0.0737226
*R24 IN1 3 686.333
XR0 IN1 3 RNW W=45u L=14.5u
D25 VSS IN1 DNWELLPSUB  AREA=0.207105
D26 IN1 VDD DPDIFFNWELL  AREA=0.0104896
D27 3 VDD DPDIFFNWELL  AREA=0.00302336
D28 VSS 3 DNDIFFPSUB  AREA=0.0154093
.ends
*
*
* File: IPAD3U.sp
* Created: Wed Apr 29 12:58:18 2026
* Program "Calibre xRC"
* Version "v2017.2_16.14"
*
.subckt IPAD3U VSS IN1 VDD OUT1
M0 OUT1 8 VDD VDD P L=1.5e-06 W=2e-05 AD=7.8e-11 AS=7.4e-11 PD=4.78e-05
+ PS=4.74e-05 NRD=0.0975 NRS=0.0975
M1 OUT1 8 VDD VDD P L=1.5e-06 W=2e-05 AD=7.8e-11 AS=7.8e-11 PD=4.78e-05
+ PS=4.78e-05 NRD=0.0975 NRS=0.0975
M2 OUT1 8 VDD VDD P L=1.5e-06 W=2e-05 AD=7.4e-11 AS=7.8e-11 PD=4.74e-05
+ PS=4.78e-05 NRD=0.0975 NRS=0.0975
M3 6 3 VDD VDD P L=2.5e-06 W=1.5e-05 AD=5.85e-11 AS=5.55e-11 PD=3.78e-05
+ PS=3.74e-05 NRD=0.13 NRS=0.13
M4 VDD 3 6 VDD P L=2.5e-06 W=1.5e-05 AD=5.85e-11 AS=5.85e-11 PD=3.78e-05
+ PS=3.78e-05 NRD=0.13 NRS=0.13
M5 VDD 3 6 VDD P L=2.5e-06 W=1.5e-05 AD=5.85e-11 AS=5.85e-11 PD=3.78e-05
+ PS=3.78e-05 NRD=0.13 NRS=0.13
M6 VSS 8 6 VDD P L=2.5e-06 W=1.5e-05 AD=5.85e-11 AS=5.85e-11 PD=3.78e-05
+ PS=3.78e-05 NRD=0.13 NRS=0.13
M7 VSS 8 6 VDD P L=2.5e-06 W=1.5e-05 AD=5.85e-11 AS=5.85e-11 PD=3.78e-05
+ PS=3.78e-05 NRD=0.13 NRS=0.13
M8 VSS 8 6 VDD P L=2.5e-06 W=1.5e-05 AD=5.85e-11 AS=5.85e-11 PD=3.78e-05
+ PS=3.78e-05 NRD=0.13 NRS=0.13
M9 VSS 8 6 VDD P L=2.5e-06 W=1.5e-05 AD=5.85e-11 AS=5.85e-11 PD=3.78e-05
+ PS=3.78e-05 NRD=0.13 NRS=0.13
M10 VSS 8 6 VDD P L=2.5e-06 W=1.5e-05 AD=5.85e-11 AS=5.85e-11 PD=3.78e-05
+ PS=3.78e-05 NRD=0.13 NRS=0.13
M11 VSS 8 6 VDD P L=2.5e-06 W=1.5e-05 AD=5.85e-11 AS=8.15e-11 PD=3.78e-05
+ PS=4.84e-05 NRD=0.13 NRS=0.15
M12 8 3 6 VDD P L=2.5e-06 W=2e-05 AD=7.8e-11 AS=8.15e-11 PD=4.78e-05 PS=4.84e-05
+ NRD=0.0975 NRS=0.0975
M13 8 3 6 VDD P L=2.5e-06 W=2e-05 AD=7.8e-11 AS=7.8e-11 PD=4.78e-05 PS=4.78e-05
+ NRD=0.0975 NRS=0.0975
M14 8 3 6 VDD P L=2.5e-06 W=2e-05 AD=7.8e-11 AS=7.8e-11 PD=4.78e-05 PS=4.78e-05
+ NRD=0.0975 NRS=0.0975
M15 8 3 6 VDD P L=2.5e-06 W=2e-05 AD=7.8e-11 AS=7.4e-11 PD=4.78e-05 PS=4.74e-05
+ NRD=0.0975 NRS=0.0975
M16 IN1 VSS VDD VDD P L=3e-06 W=2.5e-06 AD=2.4175e-11 AS=2.4805e-11 PD=2.11e-05
+ PS=2.14e-05 NRD=0.3 NRS=0.592683
M17 VSS 8 OUT1 VSS N L=1.2e-06 W=1.75e-05 AD=6.825e-11 AS=6.475e-11 PD=4.28e-05
+ PS=4.24e-05 NRD=0.111429 NRS=0.111429
M18 VSS 8 OUT1 VSS N L=1.2e-06 W=1.75e-05 AD=6.825e-11 AS=6.475e-11 PD=4.28e-05
+ PS=4.24e-05 NRD=0.111429 NRS=0.111429
M19 8 3 5 VSS N L=2e-06 W=2e-05 AD=7.8e-11 AS=7.4e-11 PD=4.78e-05 PS=4.74e-05
+ NRD=0.0975 NRS=0.0975
M20 8 3 5 VSS N L=2e-06 W=2e-05 AD=7.8e-11 AS=8.275e-11 PD=4.78e-05 PS=4.84e-05
+ NRD=0.0975 NRS=0.0975
M21 5 8 VDD VSS N L=2e-06 W=1.75e-05 AD=8.275e-11 AS=6.825e-11 PD=4.84e-05
+ PS=4.28e-05 NRD=0.122857 NRS=0.111429
M22 5 8 VDD VSS N L=2e-06 W=1.75e-05 AD=1.234e-10 AS=6.825e-11 PD=6.94e-05
+ PS=4.28e-05 NRD=0.128571 NRS=0.111429
M23 5 3 VSS VSS N L=2e-06 W=3e-05 AD=1.234e-10 AS=1.24715e-10 PD=6.94e-05
+ PS=6.05e-05 NRD=0.0862963 NRS=0.0737226
*R24 IN1 3 686.333
XR0 IN1 3 RNW W=45u L=14.5u
D25 VSS IN1 DNWELLPSUB  AREA=0.207105
D26 IN1 VDD DPDIFFNWELL  AREA=0.0104896
D27 3 VDD DPDIFFNWELL  AREA=0.00302336
D28 VSS 3 DNDIFFPSUB  AREA=0.0154093
.ends
*
*
* File: OPAD02.sp
* Created: Mon Apr 27 16:25:09 2026
* Program "Calibre xRC"
* Version "v2017.2_16.14"
*
.subckt OPAD02 VSS PAD IN1 VDD
M0 VDD IN1 PAD VDD P L=1.8e-06 W=8.7e-05 AD=6.003e-10 AS=5.916e-10 PD=0.0001878
+ PS=0.0001876 NRD=0.0706897 NRS=0.0165517
M1 PAD IN1 VDD VDD P L=1.8e-06 W=8.7e-05 AD=6.003e-10 AS=6.003e-10 PD=0.0001878
+ PS=0.0001878 NRD=0.033908 NRS=0.0224138
M2 VDD IN1 PAD VDD P L=1.8e-06 W=8.7e-05 AD=3.219e-10 AS=6.003e-10 PD=0.0001814
+ PS=0.0001878 NRD=0.0637931 NRS=0.0162069
M3 VSS IN1 PAD VSS N L=1.5e-06 W=6.35e-05 AD=4.3815e-10 AS=4.2545e-10
+ PD=0.0001408 PS=0.0001404 NRD=0.0769029 NRS=0.0222047
M4 PAD IN1 VSS VSS N L=1.5e-06 W=6.35e-05 AD=4.7625e-10 AS=4.3815e-10
+ PD=0.000142 PS=0.0001408 NRD=0.0496063 NRS=0.0419573
M5 VSS IN1 PAD VSS N L=1.5e-06 W=6.35e-05 AD=2.3495e-10 AS=4.7625e-10
+ PD=0.0001344 PS=0.000142 NRD=0.106299 NRS=0.0240945
D6 VSS PAD DNWELLPSUB  AREA=0.196343
.ends
*
*
* File: OPAD04.sp
* Created: Wed Apr 29 12:58:22 2026
* Program "Calibre xRC"
* Version "v2017.2_16.14"
*
.subckt OPAD04 VSS PAD IN1 VDD
M0 VDD IN1 PAD VDD P L=1.8e-06 W=9e-05 AD=6.21e-10 AS=6.12e-10 PD=0.0001938
+ PS=0.0001936 NRD=0.0566667 NRS=0.016
M1 PAD IN1 VDD VDD P L=1.8e-06 W=9e-05 AD=6.21e-10 AS=6.21e-10 PD=0.0001938
+ PS=0.0001938 NRD=0.0358333 NRS=0.0216667
M2 VDD IN1 PAD VDD P L=1.8e-06 W=9e-05 AD=3.33e-10 AS=6.21e-10 PD=0.0001874
+ PS=0.0001938 NRD=0.0566667 NRS=0.0156667
M3 VSS IN1 PAD VSS N L=1.5e-06 W=6.35e-05 AD=4.3815e-10 AS=4.2545e-10
+ PD=0.0001408 PS=0.0001404 NRD=0.0769029 NRS=0.0222047
M4 PAD IN1 VSS VSS N L=1.5e-06 W=6.35e-05 AD=4.7625e-10 AS=4.3815e-10
+ PD=0.000142 PS=0.0001408 NRD=0.0511811 NRS=0.0419573
M5 VSS IN1 PAD VSS N L=1.5e-06 W=6.35e-05 AD=4.6115e-10 AS=4.7625e-10
+ PD=0.0001416 PS=0.000142 NRD=0.0716535 NRS=0.023622
M6 PAD IN1 VSS VSS N L=1.5e-06 W=5.95e-05 AD=4.01625e-10 AS=4.6115e-10
+ PD=0.0001325 PS=0.0001416 NRD=0.0651261 NRS=0.0434174
D7 VSS PAD DNWELLPSUB  AREA=0.196343
.ends
*
*
* File: PVDD01.sp
* Created: Wed Apr 29 12:58:39 2026
* Program "Calibre xRC"
* Version "v2017.2_16.14"
*
.subckt PVDD01 VDD VSS
D0 VSS VDD DNWELLPSUB  AREA=0.166949
.ends
*
*
* File: PVSS01.sp
* Created: Wed Apr 29 12:58:41 2026
* Program "Calibre xRC"
* Version "v2017.2_16.14"
*
.subckt PVSS01 VSS VDD
D0 VSS VSS DNWELLPSUB  AREA=0.166949
.ends
*
*

.subckt IPAD00 VSS IN1 OUT1 VDD
XR0 IN1 OUT1 RNW W=45u L=14.5u
D1 VSS IN1 DNWELLPSUB  AREA=0.207105
D2 IN1 VDD DPDIFFNWELL  AREA=0.0104896
D3 OUT1 VDD DPDIFFNWELL  AREA=0.00302336
D4 VSS OUT1 DNDIFFPSUB  AREA=0.0154093
.ends

.subckt AIPAD00 VSS IN1 VDD
XR0 IN1 OUT1 RNW W=45u L=14.5u
D1 VSS IN1 DNWELLPSUB  AREA=0.207105
D2 IN1 VDD DPDIFFNWELL  AREA=0.0104896
D3 OUT1 VDD DPDIFFNWELL  AREA=0.00302336
D4 VSS OUT1 DNDIFFPSUB  AREA=0.0154093
.ends

.subckt RNW N1 N2  W='W' L='L'
R1 N1 N2 '2680*(L/W)' RNW
.ENDS RNW

.subckt RPP N1 N2  W='W' L='L'
R1 N1 N2   '31*(L/W)' RPP
.ENDS RPP

.subckt RNP N1 N2  W='W' L='L'
R1 N1 N2   '23*(L/W)' RNP
.ENDS RNP

.subckt RNDIFF N1 N2  W='W' L='L'
R1 N1 N2   '30*(L/W)' RNDIFF
.ENDS RNDIFF

.subckt RPDIFF N1 N2  W='W' L='L'
R1 N1 N2   '68*(L/W)' RPDIFF
.ENDS RPDIFF
